** sch_path: /foss/designs/ENGN1600-CAD6/schematics/16bit-2-1mux/16bit21.sch
.subckt 16bit21 S A0 Y0 B0 A1 Y1 B1 A2 Y2 B2 A3 Y3 B3 A4 Y4 B4 A5 Y5 B5 A6 Y6 B6 A7 Y7 B7 A8 Y8 B8 A9 Y9 B9 A10 Y10 B10 A11 Y11
+ B11 A12 Y12 B12 A13 Y13 B13 A14 Y14 B14 A15 Y15 B15
*.PININFO A0:I B0:I S:I Y0:O A1:I B1:I Y1:O A2:I B2:I Y2:O A3:I B3:I Y3:O A4:I B4:I Y4:O A5:I B5:I Y5:O A6:I B6:I Y6:O A7:I B7:I
*+ Y7:O A8:I B8:I Y8:O A9:I B9:I Y9:O A10:I B10:I Y10:O A11:I B11:I Y11:O A12:I B12:I Y12:O A13:I B13:I Y13:O A14:I B14:I Y14:O A15:I
*+ B15:I Y15:O
x1 A0 S Y0 B0 MUX21
x2 A1 S Y1 B1 MUX21
x3 A2 S Y2 B2 MUX21
x4 A3 S Y3 B3 MUX21
x5 A4 S Y4 B4 MUX21
x6 A5 S Y5 B5 MUX21
x7 A6 S Y6 B6 MUX21
x8 A7 S Y7 B7 MUX21
x9 A8 S Y8 B8 MUX21
x10 A9 S Y9 B9 MUX21
x11 A10 S Y10 B10 MUX21
x12 A11 S Y11 B11 MUX21
x13 A12 S Y12 B12 MUX21
x14 A13 S Y13 B13 MUX21
x15 A14 S Y14 B14 MUX21
x16 A15 S Y15 B15 MUX21
.ends

* expanding   symbol:  schematics/16bit-2-1mux/MUX21.sym # of pins=4
** sym_path: /foss/designs/ENGN1600-CAD6/schematics/16bit-2-1mux/MUX21.sym
** sch_path: /foss/designs/ENGN1600-CAD6/schematics/16bit-2-1mux/MUX21.sch
.subckt MUX21 IN0 S OUT IN1
*.PININFO OUT:O IN0:I IN1:I S:I
M3 net1 IN1 net2 vdd pfet_03v3 L=0.28u W=2u nf=1 m=1
M4 net2 IN0 vdd vdd pfet_03v3 L=0.28u W=2u nf=1 m=1
M1 net1 IN0 net3 GND nfet_03v3 L=0.28u W=1u nf=1 m=1
M2 net3 Sb GND GND nfet_03v3 L=0.28u W=1u nf=1 m=1
M5 net1 S net2 vdd pfet_03v3 L=0.28u W=2u nf=1 m=1
M6 net2 Sb vdd vdd pfet_03v3 L=0.28u W=2u nf=1 m=1
M7 net1 IN1 net4 GND nfet_03v3 L=0.28u W=1u nf=1 m=1
M8 net4 S GND GND nfet_03v3 L=0.28u W=1u nf=1 m=1
x3 Sb S INV
x1 OUT net1 INV
.ends

* expanding   symbol:  schematics/16bit-2-1mux/INV.sym # of pins=2
** sym_path: /foss/designs/ENGN1600-CAD6/schematics/16bit-2-1mux/INV.sym
** sch_path: /foss/designs/ENGN1600-CAD6/schematics/16bit-2-1mux/INV.sch
.subckt INV OUT IN
*.PININFO IN:I OUT:O
M1 OUT IN VDD VDD pfet_03v3 L=0.28u W=1u nf=1 m=1
M2 OUT IN GND GND nfet_03v3 L=0.28u W=0.5u nf=1 m=1
.ends

.GLOBAL vdd
.GLOBAL GND
.GLOBAL VDD
