** sch_path: /foss/designs/CAD2/TG.sch
.subckt TG in vss vdd c cbar out
*.PININFO in:I out:O vss:B vdd:B c:B cbar:B
M1 out cbar in vdd pfet_03v3 L=0.28u W=2u nf=1 m=1
M2 in c out vss nfet_03v3 L=0.28u W=1u nf=1 m=1
.ends
