* Extracted by KLayout with GF180MCU LVS runset on : 13/02/2026 02:39

.SUBCKT TG in out vdd c cbar vss
M$1 in cbar out vdd pfet_03v3 L=0.28U W=2U AS=1.3P AD=1.3P PS=5.3U PD=5.3U
M$2 out c in vss nfet_03v3 L=0.28U W=1U AS=0.61P AD=0.61P PS=3.22U PD=3.22U
.ENDS TG
