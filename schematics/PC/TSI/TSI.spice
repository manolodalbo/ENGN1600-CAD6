** sch_path: /foss/designs/CAD2/TSI/TSI.sch
.subckt TSI vdd c out in cbar vss
*.PININFO in:I out:O vdd:B vss:B cbar:B c:B
M1 net1 c vdd vdd pfet_03v3 L=0.28u W=4u nf=1 m=1
M2 out in net1 vdd pfet_03v3 L=0.28u W=4u nf=1 m=1
M3 out in net2 vss nfet_03v3 L=0.28u W=2u nf=1 m=1
M4 net2 cbar vss vss nfet_03v3 L=0.28u W=2u nf=1 m=1
.ends
