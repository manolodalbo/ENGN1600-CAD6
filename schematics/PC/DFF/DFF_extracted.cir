* Extracted by KLayout with GF180MCU LVS runset on : 13/02/2026 07:58

.SUBCKT DFF c vss cbar D Q RSTn vdd Qb CLK
M$1 \$7 \$6 vdd vdd pfet_03v3 L=0.28U W=1U AS=0.65P AD=0.65P PS=3.3U PD=3.3U
M$2 Q \$11 vdd vdd pfet_03v3 L=0.28U W=1U AS=0.65P AD=0.65P PS=3.3U PD=3.3U
M$3 \$11 \$9 vdd vdd pfet_03v3 L=0.28U W=1U AS=0.65P AD=0.26P PS=3.3U PD=1.52U
M$4 vdd RSTn \$11 vdd pfet_03v3 L=0.28U W=1U AS=0.26P AD=0.65P PS=1.52U PD=3.3U
M$5 \$9 cbar \$7 vdd pfet_03v3 L=0.28U W=2U AS=1.3P AD=1.3P PS=5.3U PD=5.3U
M$6 \$18 c vdd vdd pfet_03v3 L=0.28U W=4U AS=2.6P AD=1.04P PS=9.3U PD=4.52U
M$7 \$6 D \$18 vdd pfet_03v3 L=0.28U W=4U AS=1.04P AD=2.6P PS=4.52U PD=9.3U
M$8 Qb \$32 vdd vdd pfet_03v3 L=0.28U W=1U AS=0.65P AD=0.65P PS=3.3U PD=3.3U
M$9 \$32 \$11 vdd vdd pfet_03v3 L=0.28U W=1U AS=0.65P AD=0.65P PS=3.3U PD=3.3U
M$10 \$34 RSTn vdd vdd pfet_03v3 L=0.28U W=1U AS=0.65P AD=0.26P PS=3.3U PD=1.52U
M$11 vdd \$7 \$34 vdd pfet_03v3 L=0.28U W=1U AS=0.26P AD=0.65P PS=1.52U PD=3.3U
M$12 \$34 cbar \$6 vdd pfet_03v3 L=0.28U W=2U AS=1.3P AD=1.3P PS=5.3U PD=5.3U
M$13 \$42 \$11 \$9 vdd pfet_03v3 L=0.28U W=4U AS=2.6P AD=1.04P PS=9.3U PD=4.52U
M$14 vdd c \$42 vdd pfet_03v3 L=0.28U W=4U AS=1.04P AD=2.6P PS=4.52U PD=9.3U
M$15 vdd CLK cbar vdd pfet_03v3 L=0.28U W=1U AS=0.65P AD=0.65P PS=3.3U PD=3.3U
M$16 vdd cbar c vdd pfet_03v3 L=0.28U W=1U AS=0.65P AD=0.65P PS=3.3U PD=3.3U
M$17 \$5 cbar vss vss nfet_03v3 L=0.28U W=2U AS=1.22P AD=0.52P PS=5.22U PD=2.52U
M$18 \$6 D \$5 vss nfet_03v3 L=0.28U W=2U AS=0.52P AD=1.22P PS=2.52U PD=5.22U
M$19 \$7 \$6 vss vss nfet_03v3 L=0.28U W=1U AS=0.61P AD=0.61P PS=3.22U PD=3.22U
M$20 Q \$11 vss vss nfet_03v3 L=0.28U W=1U AS=0.61P AD=0.61P PS=3.22U PD=3.22U
M$21 \$9 c \$7 vss nfet_03v3 L=0.28U W=1U AS=0.61P AD=0.61P PS=3.22U PD=3.22U
M$22 \$16 \$9 vss vss nfet_03v3 L=0.28U W=1U AS=0.61P AD=0.61P PS=3.22U PD=3.22U
M$23 \$11 RSTn \$16 vss nfet_03v3 L=0.28U W=1U AS=0.61P AD=0.61P PS=3.22U
+ PD=3.22U
M$24 Qb \$32 vss vss nfet_03v3 L=0.28U W=1U AS=0.61P AD=0.61P PS=3.22U PD=3.22U
M$25 \$32 \$11 vss vss nfet_03v3 L=0.28U W=1U AS=0.61P AD=0.61P PS=3.22U
+ PD=3.22U
M$26 \$31 \$11 \$9 vss nfet_03v3 L=0.28U W=2U AS=1.22P AD=0.52P PS=5.22U
+ PD=2.52U
M$27 vss cbar \$31 vss nfet_03v3 L=0.28U W=2U AS=0.52P AD=1.22P PS=2.52U
+ PD=5.22U
M$28 \$34 c \$6 vss nfet_03v3 L=0.28U W=1U AS=0.61P AD=0.61P PS=3.22U PD=3.22U
M$29 vss \$7 \$35 vss nfet_03v3 L=0.28U W=1U AS=0.61P AD=0.61P PS=3.22U PD=3.22U
M$30 \$35 RSTn \$34 vss nfet_03v3 L=0.28U W=1U AS=0.61P AD=0.61P PS=3.22U
+ PD=3.22U
M$31 vss CLK cbar vss nfet_03v3 L=0.28U W=1U AS=0.61P AD=0.61P PS=3.22U PD=3.22U
M$32 vss cbar c vss nfet_03v3 L=0.28U W=1U AS=0.61P AD=0.61P PS=3.22U PD=3.22U
.ENDS DFF
