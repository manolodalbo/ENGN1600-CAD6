** sch_path: /foss/designs/CAD2/DFF/DFF.sch
.subckt DFF vdd RSTn D Q Qb CLK vss
*.PININFO Qb:O Q:O D:I RSTn:I vdd:B vss:B CLK:I
x13 net1 vss vdd c cbar net6 TG
x12 net2 vss vdd c cbar net3 TG
x3 vdd c net1 D cbar vss TSI
x1 vdd c net3 net4 cbar vss TSI
x2 vdd CLK cbar vss inv
x4 vdd cbar c vss inv
x7 vdd net4 net5 vss inv
x8 vdd net5 Qb vss inv
x9 vdd net1 net2 vss inv
x6 vdd net4 Q vss inv
x5 vdd net4 RSTn net3 vss NAND2
x10 vdd net6 RSTn net2 vss NAND2
.ends

* expanding   symbol:  CAD2/TG/TG.sym # of pins=6
** sym_path: /foss/designs/CAD2/TG/TG.sym
** sch_path: /foss/designs/CAD2/TG/TG.sch
.subckt TG in vss vdd c cbar out
*.PININFO in:I out:O vss:B vdd:B c:B cbar:B
M1 out cbar in vdd pfet_03v3 L=0.28u W=2u nf=1 m=1
M2 in c out vss nfet_03v3 L=0.28u W=1u nf=1 m=1
.ends

* expanding   symbol:  CAD2/TSI/TSI.sym # of pins=6
** sym_path: /foss/designs/CAD2/TSI/TSI.sym
** sch_path: /foss/designs/CAD2/TSI/TSI.sch
.subckt TSI vdd c out in cbar vss
*.PININFO in:I out:O vdd:B vss:B cbar:B c:B
M1 net1 c vdd vdd pfet_03v3 L=0.28u W=4u nf=1 m=1
M2 out in net1 vdd pfet_03v3 L=0.28u W=4u nf=1 m=1
M3 out in net2 vss nfet_03v3 L=0.28u W=2u nf=1 m=1
M4 net2 cbar vss vss nfet_03v3 L=0.28u W=2u nf=1 m=1
.ends

* expanding   symbol:  CAD2/INV/inv.sym # of pins=4
** sym_path: /foss/designs/CAD2/INV/inv.sym
** sch_path: /foss/designs/CAD2/INV/inv.sch
.subckt inv vdd IN OUT vss
*.PININFO IN:I OUT:O vdd:B vss:B
M1 OUT IN vss vss nfet_03v3 L=0.28u W=1u nf=1 m=1
M2 OUT IN vdd vdd pfet_03v3 L=0.28u W=1u nf=1 m=1
.ends

* expanding   symbol:  CAD2/NAND2/NAND2.sym # of pins=5
** sym_path: /foss/designs/CAD2/NAND2/NAND2.sym
** sch_path: /foss/designs/CAD2/NAND2/NAND2.sch
.subckt NAND2 vdd OUT IN0 IN1 vss
*.PININFO vdd:B vss:B OUT:O IN0:I IN1:I
M1 WK IN1 vss vss nfet_03v3 L=0.28u W=1u nf=1 m=1
M2 OUT IN0 WK vss nfet_03v3 L=0.28u W=1u nf=1 m=1
M3 OUT IN1 vdd vdd pfet_03v3 L=0.28u W=1u nf=1 m=1
M4 OUT IN0 vdd vdd pfet_03v3 L=0.28u W=1u nf=1 m=1
.ends
