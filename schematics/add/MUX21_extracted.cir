* Extracted by KLayout with GF180MCU LVS runset on : 16/03/2026 00:12

.SUBCKT MUX21 GND OUT S VDD IN1 IN0
M$1 \$2 S VDD VDD pfet_03v3 L=0.28U W=1U AS=0.635P AD=0.65P PS=3.27U PD=3.3U
M$2 OUT \$3 VDD VDD pfet_03v3 L=0.28U W=1U AS=0.53P AD=0.545P PS=3.06U PD=3.09U
M$3 \$3 S \$15 VDD pfet_03v3 L=0.28U W=2U AS=1.09P AD=0.725P PS=5.09U PD=2.725U
M$4 \$15 IN1 \$3 VDD pfet_03v3 L=0.28U W=2U AS=0.725P AD=0.675P PS=2.725U
+ PD=2.675U
M$5 VDD IN0 \$15 VDD pfet_03v3 L=0.28U W=2U AS=0.675P AD=0.725P PS=2.675U
+ PD=2.725U
M$6 \$15 \$2 VDD VDD pfet_03v3 L=0.28U W=2U AS=0.725P AD=1.3P PS=2.725U PD=5.3U
M$7 \$2 S GND GND nfet_03v3 L=0.28U W=0.5U AS=0.3175P AD=0.315P PS=2.27U
+ PD=2.26U
M$8 \$13 S GND GND nfet_03v3 L=0.28U W=1U AS=0.54P AD=0.3625P PS=3.08U PD=1.725U
M$9 \$3 IN1 \$13 GND nfet_03v3 L=0.28U W=1U AS=0.3625P AD=0.3375P PS=1.725U
+ PD=1.675U
M$10 \$12 IN0 \$3 GND nfet_03v3 L=0.28U W=1U AS=0.3375P AD=0.3625P PS=1.675U
+ PD=1.725U
M$11 GND \$2 \$12 GND nfet_03v3 L=0.28U W=1U AS=0.3625P AD=0.65P PS=1.725U
+ PD=3.3U
M$12 OUT \$3 GND GND nfet_03v3 L=0.28U W=0.5U AS=0.265P AD=0.2625P PS=2.06U
+ PD=2.05U
.ENDS MUX21
