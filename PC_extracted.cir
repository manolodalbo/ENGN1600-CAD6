* Extracted by KLayout with GF180MCU LVS runset on : 18/04/2026 03:41

.SUBCKT PC vss RSTn Qb15 VDD CLK D15 Q15 D14 Q14 Qb14 D13 Q13 Qb13 D12 Q12 Qb12
+ D11 Q11 Qb11 D10 Q10 Qb10 D9 Q9 Qb9 Q8 Qb8 D8 Qb7 D7 Q7 Q6 Qb6 D6 Qb5 D5 Q5
+ Q4 Qb4 D4 Qb3 D3 Q3 Q2 Qb2 D2 Q1 Qb1 D1 Q0 Qb0 D0
M$1 \$9 \$19 VDD VDD pfet_03v3 L=0.28U W=1U AS=0.65P AD=0.65P PS=3.3U PD=3.3U
M$2 Qb15 \$9 VDD VDD pfet_03v3 L=0.28U W=1U AS=0.65P AD=0.65P PS=3.3U PD=3.3U
M$3 \$2 CLK VDD VDD pfet_03v3 L=0.28U W=1U AS=0.65P AD=0.65P PS=3.3U PD=3.3U
M$4 \$4 \$2 VDD VDD pfet_03v3 L=0.28U W=1U AS=0.65P AD=0.65P PS=3.3U PD=3.3U
M$5 \$37 \$4 VDD VDD pfet_03v3 L=0.28U W=1U AS=0.65P AD=0.65P PS=3.3U PD=3.3U
M$6 \$19 RSTn VDD VDD pfet_03v3 L=0.28U W=1U AS=0.65P AD=0.65P PS=3.3U PD=3.3U
M$7 \$19 \$7 VDD VDD pfet_03v3 L=0.28U W=1U AS=0.65P AD=0.65P PS=3.3U PD=3.3U
M$8 \$38 \$19 \$7 VDD pfet_03v3 L=0.28U W=1U AS=0.65P AD=0.65P PS=3.3U PD=3.3U
M$9 VDD \$4 \$38 VDD pfet_03v3 L=0.28U W=1U AS=0.65P AD=0.65P PS=3.3U PD=3.3U
M$10 Q15 \$19 VDD VDD pfet_03v3 L=0.28U W=1U AS=0.65P AD=0.65P PS=3.3U PD=3.3U
M$11 \$55 CLK VDD VDD pfet_03v3 L=0.28U W=1U AS=0.65P AD=0.65P PS=3.3U PD=3.3U
M$12 \$57 \$55 VDD VDD pfet_03v3 L=0.28U W=1U AS=0.65P AD=0.65P PS=3.3U PD=3.3U
M$13 \$87 \$57 VDD VDD pfet_03v3 L=0.28U W=1U AS=0.65P AD=0.65P PS=3.3U PD=3.3U
M$14 \$14 D15 \$37 VDD pfet_03v3 L=0.28U W=1U AS=0.65P AD=0.65P PS=3.3U PD=3.3U
M$15 \$6 \$2 \$14 VDD pfet_03v3 L=0.28U W=1U AS=0.65P AD=0.65P PS=3.3U PD=3.3U
M$16 VDD RSTn \$6 VDD pfet_03v3 L=0.28U W=1U AS=0.65P AD=0.65P PS=3.3U PD=3.3U
M$17 \$6 \$16 VDD VDD pfet_03v3 L=0.28U W=1U AS=0.65P AD=0.65P PS=3.3U PD=3.3U
M$18 VDD \$14 \$16 VDD pfet_03v3 L=0.28U W=1U AS=0.65P AD=0.65P PS=3.3U PD=3.3U
M$19 \$7 \$2 \$16 VDD pfet_03v3 L=0.28U W=1U AS=0.65P AD=0.65P PS=3.3U PD=3.3U
M$20 \$65 RSTn VDD VDD pfet_03v3 L=0.28U W=1U AS=0.65P AD=0.65P PS=3.3U PD=3.3U
M$21 \$65 \$56 VDD VDD pfet_03v3 L=0.28U W=1U AS=0.65P AD=0.65P PS=3.3U PD=3.3U
M$22 \$88 \$65 \$56 VDD pfet_03v3 L=0.28U W=1U AS=0.65P AD=0.65P PS=3.3U PD=3.3U
M$23 VDD \$57 \$88 VDD pfet_03v3 L=0.28U W=1U AS=0.65P AD=0.65P PS=3.3U PD=3.3U
M$24 Q14 \$65 VDD VDD pfet_03v3 L=0.28U W=1U AS=0.65P AD=0.65P PS=3.3U PD=3.3U
M$25 \$68 \$65 VDD VDD pfet_03v3 L=0.28U W=1U AS=0.65P AD=0.65P PS=3.3U PD=3.3U
M$26 Qb14 \$68 VDD VDD pfet_03v3 L=0.28U W=1U AS=0.65P AD=0.65P PS=3.3U PD=3.3U
M$27 \$105 CLK VDD VDD pfet_03v3 L=0.28U W=1U AS=0.65P AD=0.65P PS=3.3U PD=3.3U
M$28 \$107 \$105 VDD VDD pfet_03v3 L=0.28U W=1U AS=0.65P AD=0.65P PS=3.3U
+ PD=3.3U
M$29 \$137 \$107 VDD VDD pfet_03v3 L=0.28U W=1U AS=0.65P AD=0.65P PS=3.3U
+ PD=3.3U
M$30 \$60 D14 \$87 VDD pfet_03v3 L=0.28U W=1U AS=0.65P AD=0.65P PS=3.3U PD=3.3U
M$31 \$61 \$55 \$60 VDD pfet_03v3 L=0.28U W=1U AS=0.65P AD=0.65P PS=3.3U PD=3.3U
M$32 VDD RSTn \$61 VDD pfet_03v3 L=0.28U W=1U AS=0.65P AD=0.65P PS=3.3U PD=3.3U
M$33 \$61 \$63 VDD VDD pfet_03v3 L=0.28U W=1U AS=0.65P AD=0.65P PS=3.3U PD=3.3U
M$34 VDD \$60 \$63 VDD pfet_03v3 L=0.28U W=1U AS=0.65P AD=0.65P PS=3.3U PD=3.3U
M$35 \$56 \$55 \$63 VDD pfet_03v3 L=0.28U W=1U AS=0.65P AD=0.65P PS=3.3U PD=3.3U
M$36 \$115 RSTn VDD VDD pfet_03v3 L=0.28U W=1U AS=0.65P AD=0.65P PS=3.3U PD=3.3U
M$37 \$115 \$106 VDD VDD pfet_03v3 L=0.28U W=1U AS=0.65P AD=0.65P PS=3.3U
+ PD=3.3U
M$38 \$138 \$115 \$106 VDD pfet_03v3 L=0.28U W=1U AS=0.65P AD=0.65P PS=3.3U
+ PD=3.3U
M$39 VDD \$107 \$138 VDD pfet_03v3 L=0.28U W=1U AS=0.65P AD=0.65P PS=3.3U
+ PD=3.3U
M$40 Q13 \$115 VDD VDD pfet_03v3 L=0.28U W=1U AS=0.65P AD=0.65P PS=3.3U PD=3.3U
M$41 \$118 \$115 VDD VDD pfet_03v3 L=0.28U W=1U AS=0.65P AD=0.65P PS=3.3U
+ PD=3.3U
M$42 Qb13 \$118 VDD VDD pfet_03v3 L=0.28U W=1U AS=0.65P AD=0.65P PS=3.3U PD=3.3U
M$43 \$155 CLK VDD VDD pfet_03v3 L=0.28U W=1U AS=0.65P AD=0.65P PS=3.3U PD=3.3U
M$44 \$157 \$155 VDD VDD pfet_03v3 L=0.28U W=1U AS=0.65P AD=0.65P PS=3.3U
+ PD=3.3U
M$45 \$187 \$157 VDD VDD pfet_03v3 L=0.28U W=1U AS=0.65P AD=0.65P PS=3.3U
+ PD=3.3U
M$46 \$110 D13 \$137 VDD pfet_03v3 L=0.28U W=1U AS=0.65P AD=0.65P PS=3.3U
+ PD=3.3U
M$47 \$111 \$105 \$110 VDD pfet_03v3 L=0.28U W=1U AS=0.65P AD=0.65P PS=3.3U
+ PD=3.3U
M$48 VDD RSTn \$111 VDD pfet_03v3 L=0.28U W=1U AS=0.65P AD=0.65P PS=3.3U PD=3.3U
M$49 \$111 \$113 VDD VDD pfet_03v3 L=0.28U W=1U AS=0.65P AD=0.65P PS=3.3U
+ PD=3.3U
M$50 VDD \$110 \$113 VDD pfet_03v3 L=0.28U W=1U AS=0.65P AD=0.65P PS=3.3U
+ PD=3.3U
M$51 \$106 \$105 \$113 VDD pfet_03v3 L=0.28U W=1U AS=0.65P AD=0.65P PS=3.3U
+ PD=3.3U
M$52 \$165 RSTn VDD VDD pfet_03v3 L=0.28U W=1U AS=0.65P AD=0.65P PS=3.3U PD=3.3U
M$53 \$165 \$156 VDD VDD pfet_03v3 L=0.28U W=1U AS=0.65P AD=0.65P PS=3.3U
+ PD=3.3U
M$54 \$188 \$165 \$156 VDD pfet_03v3 L=0.28U W=1U AS=0.65P AD=0.65P PS=3.3U
+ PD=3.3U
M$55 VDD \$157 \$188 VDD pfet_03v3 L=0.28U W=1U AS=0.65P AD=0.65P PS=3.3U
+ PD=3.3U
M$56 Q12 \$165 VDD VDD pfet_03v3 L=0.28U W=1U AS=0.65P AD=0.65P PS=3.3U PD=3.3U
M$57 \$168 \$165 VDD VDD pfet_03v3 L=0.28U W=1U AS=0.65P AD=0.65P PS=3.3U
+ PD=3.3U
M$58 Qb12 \$168 VDD VDD pfet_03v3 L=0.28U W=1U AS=0.65P AD=0.65P PS=3.3U PD=3.3U
M$59 \$205 CLK VDD VDD pfet_03v3 L=0.28U W=1U AS=0.65P AD=0.65P PS=3.3U PD=3.3U
M$60 \$207 \$205 VDD VDD pfet_03v3 L=0.28U W=1U AS=0.65P AD=0.65P PS=3.3U
+ PD=3.3U
M$61 \$237 \$207 VDD VDD pfet_03v3 L=0.28U W=1U AS=0.65P AD=0.65P PS=3.3U
+ PD=3.3U
M$62 \$160 D12 \$187 VDD pfet_03v3 L=0.28U W=1U AS=0.65P AD=0.65P PS=3.3U
+ PD=3.3U
M$63 \$161 \$155 \$160 VDD pfet_03v3 L=0.28U W=1U AS=0.65P AD=0.65P PS=3.3U
+ PD=3.3U
M$64 VDD RSTn \$161 VDD pfet_03v3 L=0.28U W=1U AS=0.65P AD=0.65P PS=3.3U PD=3.3U
M$65 \$161 \$163 VDD VDD pfet_03v3 L=0.28U W=1U AS=0.65P AD=0.65P PS=3.3U
+ PD=3.3U
M$66 VDD \$160 \$163 VDD pfet_03v3 L=0.28U W=1U AS=0.65P AD=0.65P PS=3.3U
+ PD=3.3U
M$67 \$156 \$155 \$163 VDD pfet_03v3 L=0.28U W=1U AS=0.65P AD=0.65P PS=3.3U
+ PD=3.3U
M$68 \$215 RSTn VDD VDD pfet_03v3 L=0.28U W=1U AS=0.65P AD=0.65P PS=3.3U PD=3.3U
M$69 \$215 \$206 VDD VDD pfet_03v3 L=0.28U W=1U AS=0.65P AD=0.65P PS=3.3U
+ PD=3.3U
M$70 \$238 \$215 \$206 VDD pfet_03v3 L=0.28U W=1U AS=0.65P AD=0.65P PS=3.3U
+ PD=3.3U
M$71 VDD \$207 \$238 VDD pfet_03v3 L=0.28U W=1U AS=0.65P AD=0.65P PS=3.3U
+ PD=3.3U
M$72 Q11 \$215 VDD VDD pfet_03v3 L=0.28U W=1U AS=0.65P AD=0.65P PS=3.3U PD=3.3U
M$73 \$218 \$215 VDD VDD pfet_03v3 L=0.28U W=1U AS=0.65P AD=0.65P PS=3.3U
+ PD=3.3U
M$74 Qb11 \$218 VDD VDD pfet_03v3 L=0.28U W=1U AS=0.65P AD=0.65P PS=3.3U PD=3.3U
M$75 \$255 CLK VDD VDD pfet_03v3 L=0.28U W=1U AS=0.65P AD=0.65P PS=3.3U PD=3.3U
M$76 \$257 \$255 VDD VDD pfet_03v3 L=0.28U W=1U AS=0.65P AD=0.65P PS=3.3U
+ PD=3.3U
M$77 \$287 \$257 VDD VDD pfet_03v3 L=0.28U W=1U AS=0.65P AD=0.65P PS=3.3U
+ PD=3.3U
M$78 \$210 D11 \$237 VDD pfet_03v3 L=0.28U W=1U AS=0.65P AD=0.65P PS=3.3U
+ PD=3.3U
M$79 \$211 \$205 \$210 VDD pfet_03v3 L=0.28U W=1U AS=0.65P AD=0.65P PS=3.3U
+ PD=3.3U
M$80 VDD RSTn \$211 VDD pfet_03v3 L=0.28U W=1U AS=0.65P AD=0.65P PS=3.3U PD=3.3U
M$81 \$211 \$213 VDD VDD pfet_03v3 L=0.28U W=1U AS=0.65P AD=0.65P PS=3.3U
+ PD=3.3U
M$82 VDD \$210 \$213 VDD pfet_03v3 L=0.28U W=1U AS=0.65P AD=0.65P PS=3.3U
+ PD=3.3U
M$83 \$206 \$205 \$213 VDD pfet_03v3 L=0.28U W=1U AS=0.65P AD=0.65P PS=3.3U
+ PD=3.3U
M$84 \$265 RSTn VDD VDD pfet_03v3 L=0.28U W=1U AS=0.65P AD=0.65P PS=3.3U PD=3.3U
M$85 \$265 \$256 VDD VDD pfet_03v3 L=0.28U W=1U AS=0.65P AD=0.65P PS=3.3U
+ PD=3.3U
M$86 \$288 \$265 \$256 VDD pfet_03v3 L=0.28U W=1U AS=0.65P AD=0.65P PS=3.3U
+ PD=3.3U
M$87 VDD \$257 \$288 VDD pfet_03v3 L=0.28U W=1U AS=0.65P AD=0.65P PS=3.3U
+ PD=3.3U
M$88 Q10 \$265 VDD VDD pfet_03v3 L=0.28U W=1U AS=0.65P AD=0.65P PS=3.3U PD=3.3U
M$89 \$268 \$265 VDD VDD pfet_03v3 L=0.28U W=1U AS=0.65P AD=0.65P PS=3.3U
+ PD=3.3U
M$90 Qb10 \$268 VDD VDD pfet_03v3 L=0.28U W=1U AS=0.65P AD=0.65P PS=3.3U PD=3.3U
M$91 \$305 CLK VDD VDD pfet_03v3 L=0.28U W=1U AS=0.65P AD=0.65P PS=3.3U PD=3.3U
M$92 \$307 \$305 VDD VDD pfet_03v3 L=0.28U W=1U AS=0.65P AD=0.65P PS=3.3U
+ PD=3.3U
M$93 \$337 \$307 VDD VDD pfet_03v3 L=0.28U W=1U AS=0.65P AD=0.65P PS=3.3U
+ PD=3.3U
M$94 \$260 D10 \$287 VDD pfet_03v3 L=0.28U W=1U AS=0.65P AD=0.65P PS=3.3U
+ PD=3.3U
M$95 \$261 \$255 \$260 VDD pfet_03v3 L=0.28U W=1U AS=0.65P AD=0.65P PS=3.3U
+ PD=3.3U
M$96 VDD RSTn \$261 VDD pfet_03v3 L=0.28U W=1U AS=0.65P AD=0.65P PS=3.3U PD=3.3U
M$97 \$261 \$263 VDD VDD pfet_03v3 L=0.28U W=1U AS=0.65P AD=0.65P PS=3.3U
+ PD=3.3U
M$98 VDD \$260 \$263 VDD pfet_03v3 L=0.28U W=1U AS=0.65P AD=0.65P PS=3.3U
+ PD=3.3U
M$99 \$256 \$255 \$263 VDD pfet_03v3 L=0.28U W=1U AS=0.65P AD=0.65P PS=3.3U
+ PD=3.3U
M$100 \$315 RSTn VDD VDD pfet_03v3 L=0.28U W=1U AS=0.65P AD=0.65P PS=3.3U
+ PD=3.3U
M$101 \$315 \$306 VDD VDD pfet_03v3 L=0.28U W=1U AS=0.65P AD=0.65P PS=3.3U
+ PD=3.3U
M$102 \$338 \$315 \$306 VDD pfet_03v3 L=0.28U W=1U AS=0.65P AD=0.65P PS=3.3U
+ PD=3.3U
M$103 VDD \$307 \$338 VDD pfet_03v3 L=0.28U W=1U AS=0.65P AD=0.65P PS=3.3U
+ PD=3.3U
M$104 Q9 \$315 VDD VDD pfet_03v3 L=0.28U W=1U AS=0.65P AD=0.65P PS=3.3U PD=3.3U
M$105 \$318 \$315 VDD VDD pfet_03v3 L=0.28U W=1U AS=0.65P AD=0.65P PS=3.3U
+ PD=3.3U
M$106 Qb9 \$318 VDD VDD pfet_03v3 L=0.28U W=1U AS=0.65P AD=0.65P PS=3.3U PD=3.3U
M$107 \$355 CLK VDD VDD pfet_03v3 L=0.28U W=1U AS=0.65P AD=0.65P PS=3.3U PD=3.3U
M$108 \$357 \$355 VDD VDD pfet_03v3 L=0.28U W=1U AS=0.65P AD=0.65P PS=3.3U
+ PD=3.3U
M$109 \$387 \$357 VDD VDD pfet_03v3 L=0.28U W=1U AS=0.65P AD=0.65P PS=3.3U
+ PD=3.3U
M$110 \$310 D9 \$337 VDD pfet_03v3 L=0.28U W=1U AS=0.65P AD=0.65P PS=3.3U
+ PD=3.3U
M$111 \$311 \$305 \$310 VDD pfet_03v3 L=0.28U W=1U AS=0.65P AD=0.65P PS=3.3U
+ PD=3.3U
M$112 VDD RSTn \$311 VDD pfet_03v3 L=0.28U W=1U AS=0.65P AD=0.65P PS=3.3U
+ PD=3.3U
M$113 \$311 \$313 VDD VDD pfet_03v3 L=0.28U W=1U AS=0.65P AD=0.65P PS=3.3U
+ PD=3.3U
M$114 VDD \$310 \$313 VDD pfet_03v3 L=0.28U W=1U AS=0.65P AD=0.65P PS=3.3U
+ PD=3.3U
M$115 \$306 \$305 \$313 VDD pfet_03v3 L=0.28U W=1U AS=0.65P AD=0.65P PS=3.3U
+ PD=3.3U
M$116 \$364 RSTn VDD VDD pfet_03v3 L=0.28U W=1U AS=0.65P AD=0.65P PS=3.3U
+ PD=3.3U
M$117 \$364 \$356 VDD VDD pfet_03v3 L=0.28U W=1U AS=0.65P AD=0.65P PS=3.3U
+ PD=3.3U
M$118 \$388 \$364 \$356 VDD pfet_03v3 L=0.28U W=1U AS=0.65P AD=0.65P PS=3.3U
+ PD=3.3U
M$119 VDD \$357 \$388 VDD pfet_03v3 L=0.28U W=1U AS=0.65P AD=0.65P PS=3.3U
+ PD=3.3U
M$120 Q8 \$364 VDD VDD pfet_03v3 L=0.28U W=1U AS=0.65P AD=0.65P PS=3.3U PD=3.3U
M$121 \$367 \$364 VDD VDD pfet_03v3 L=0.28U W=1U AS=0.65P AD=0.65P PS=3.3U
+ PD=3.3U
M$122 Qb8 \$367 VDD VDD pfet_03v3 L=0.28U W=1U AS=0.65P AD=0.65P PS=3.3U PD=3.3U
M$123 \$405 CLK VDD VDD pfet_03v3 L=0.28U W=1U AS=0.65P AD=0.65P PS=3.3U PD=3.3U
M$124 \$406 \$405 VDD VDD pfet_03v3 L=0.28U W=1U AS=0.65P AD=0.65P PS=3.3U
+ PD=3.3U
M$125 \$437 \$406 VDD VDD pfet_03v3 L=0.28U W=1U AS=0.65P AD=0.65P PS=3.3U
+ PD=3.3U
M$126 \$359 D8 \$387 VDD pfet_03v3 L=0.28U W=1U AS=0.65P AD=0.65P PS=3.3U
+ PD=3.3U
M$127 \$360 \$355 \$359 VDD pfet_03v3 L=0.28U W=1U AS=0.65P AD=0.65P PS=3.3U
+ PD=3.3U
M$128 VDD RSTn \$360 VDD pfet_03v3 L=0.28U W=1U AS=0.65P AD=0.65P PS=3.3U
+ PD=3.3U
M$129 \$360 \$362 VDD VDD pfet_03v3 L=0.28U W=1U AS=0.65P AD=0.65P PS=3.3U
+ PD=3.3U
M$130 VDD \$359 \$362 VDD pfet_03v3 L=0.28U W=1U AS=0.65P AD=0.65P PS=3.3U
+ PD=3.3U
M$131 \$356 \$355 \$362 VDD pfet_03v3 L=0.28U W=1U AS=0.65P AD=0.65P PS=3.3U
+ PD=3.3U
M$132 \$419 RSTn VDD VDD pfet_03v3 L=0.28U W=1U AS=0.65P AD=0.65P PS=3.3U
+ PD=3.3U
M$133 \$419 \$417 VDD VDD pfet_03v3 L=0.28U W=1U AS=0.65P AD=0.65P PS=3.3U
+ PD=3.3U
M$134 \$438 \$419 \$417 VDD pfet_03v3 L=0.28U W=1U AS=0.65P AD=0.65P PS=3.3U
+ PD=3.3U
M$135 VDD \$406 \$438 VDD pfet_03v3 L=0.28U W=1U AS=0.65P AD=0.65P PS=3.3U
+ PD=3.3U
M$136 Q7 \$419 VDD VDD pfet_03v3 L=0.28U W=1U AS=0.65P AD=0.65P PS=3.3U PD=3.3U
M$137 \$409 \$419 VDD VDD pfet_03v3 L=0.28U W=1U AS=0.65P AD=0.65P PS=3.3U
+ PD=3.3U
M$138 Qb7 \$409 VDD VDD pfet_03v3 L=0.28U W=1U AS=0.65P AD=0.65P PS=3.3U PD=3.3U
M$139 \$455 CLK VDD VDD pfet_03v3 L=0.28U W=1U AS=0.65P AD=0.65P PS=3.3U PD=3.3U
M$140 \$457 \$455 VDD VDD pfet_03v3 L=0.28U W=1U AS=0.65P AD=0.65P PS=3.3U
+ PD=3.3U
M$141 \$487 \$457 VDD VDD pfet_03v3 L=0.28U W=1U AS=0.65P AD=0.65P PS=3.3U
+ PD=3.3U
M$142 \$412 D7 \$437 VDD pfet_03v3 L=0.28U W=1U AS=0.65P AD=0.65P PS=3.3U
+ PD=3.3U
M$143 \$413 \$405 \$412 VDD pfet_03v3 L=0.28U W=1U AS=0.65P AD=0.65P PS=3.3U
+ PD=3.3U
M$144 VDD RSTn \$413 VDD pfet_03v3 L=0.28U W=1U AS=0.65P AD=0.65P PS=3.3U
+ PD=3.3U
M$145 \$413 \$415 VDD VDD pfet_03v3 L=0.28U W=1U AS=0.65P AD=0.65P PS=3.3U
+ PD=3.3U
M$146 VDD \$412 \$415 VDD pfet_03v3 L=0.28U W=1U AS=0.65P AD=0.65P PS=3.3U
+ PD=3.3U
M$147 \$417 \$405 \$415 VDD pfet_03v3 L=0.28U W=1U AS=0.65P AD=0.65P PS=3.3U
+ PD=3.3U
M$148 \$464 RSTn VDD VDD pfet_03v3 L=0.28U W=1U AS=0.65P AD=0.65P PS=3.3U
+ PD=3.3U
M$149 \$464 \$456 VDD VDD pfet_03v3 L=0.28U W=1U AS=0.65P AD=0.65P PS=3.3U
+ PD=3.3U
M$150 \$488 \$464 \$456 VDD pfet_03v3 L=0.28U W=1U AS=0.65P AD=0.65P PS=3.3U
+ PD=3.3U
M$151 VDD \$457 \$488 VDD pfet_03v3 L=0.28U W=1U AS=0.65P AD=0.65P PS=3.3U
+ PD=3.3U
M$152 Q6 \$464 VDD VDD pfet_03v3 L=0.28U W=1U AS=0.65P AD=0.65P PS=3.3U PD=3.3U
M$153 \$467 \$464 VDD VDD pfet_03v3 L=0.28U W=1U AS=0.65P AD=0.65P PS=3.3U
+ PD=3.3U
M$154 Qb6 \$467 VDD VDD pfet_03v3 L=0.28U W=1U AS=0.65P AD=0.65P PS=3.3U PD=3.3U
M$155 \$505 CLK VDD VDD pfet_03v3 L=0.28U W=1U AS=0.65P AD=0.65P PS=3.3U PD=3.3U
M$156 \$506 \$505 VDD VDD pfet_03v3 L=0.28U W=1U AS=0.65P AD=0.65P PS=3.3U
+ PD=3.3U
M$157 \$537 \$506 VDD VDD pfet_03v3 L=0.28U W=1U AS=0.65P AD=0.65P PS=3.3U
+ PD=3.3U
M$158 \$459 D6 \$487 VDD pfet_03v3 L=0.28U W=1U AS=0.65P AD=0.65P PS=3.3U
+ PD=3.3U
M$159 \$460 \$455 \$459 VDD pfet_03v3 L=0.28U W=1U AS=0.65P AD=0.65P PS=3.3U
+ PD=3.3U
M$160 VDD RSTn \$460 VDD pfet_03v3 L=0.28U W=1U AS=0.65P AD=0.65P PS=3.3U
+ PD=3.3U
M$161 \$460 \$462 VDD VDD pfet_03v3 L=0.28U W=1U AS=0.65P AD=0.65P PS=3.3U
+ PD=3.3U
M$162 VDD \$459 \$462 VDD pfet_03v3 L=0.28U W=1U AS=0.65P AD=0.65P PS=3.3U
+ PD=3.3U
M$163 \$456 \$455 \$462 VDD pfet_03v3 L=0.28U W=1U AS=0.65P AD=0.65P PS=3.3U
+ PD=3.3U
M$164 \$519 RSTn VDD VDD pfet_03v3 L=0.28U W=1U AS=0.65P AD=0.65P PS=3.3U
+ PD=3.3U
M$165 \$519 \$517 VDD VDD pfet_03v3 L=0.28U W=1U AS=0.65P AD=0.65P PS=3.3U
+ PD=3.3U
M$166 \$538 \$519 \$517 VDD pfet_03v3 L=0.28U W=1U AS=0.65P AD=0.65P PS=3.3U
+ PD=3.3U
M$167 VDD \$506 \$538 VDD pfet_03v3 L=0.28U W=1U AS=0.65P AD=0.65P PS=3.3U
+ PD=3.3U
M$168 Q5 \$519 VDD VDD pfet_03v3 L=0.28U W=1U AS=0.65P AD=0.65P PS=3.3U PD=3.3U
M$169 \$509 \$519 VDD VDD pfet_03v3 L=0.28U W=1U AS=0.65P AD=0.65P PS=3.3U
+ PD=3.3U
M$170 Qb5 \$509 VDD VDD pfet_03v3 L=0.28U W=1U AS=0.65P AD=0.65P PS=3.3U PD=3.3U
M$171 \$555 CLK VDD VDD pfet_03v3 L=0.28U W=1U AS=0.65P AD=0.65P PS=3.3U PD=3.3U
M$172 \$557 \$555 VDD VDD pfet_03v3 L=0.28U W=1U AS=0.65P AD=0.65P PS=3.3U
+ PD=3.3U
M$173 \$587 \$557 VDD VDD pfet_03v3 L=0.28U W=1U AS=0.65P AD=0.65P PS=3.3U
+ PD=3.3U
M$174 \$512 D5 \$537 VDD pfet_03v3 L=0.28U W=1U AS=0.65P AD=0.65P PS=3.3U
+ PD=3.3U
M$175 \$513 \$505 \$512 VDD pfet_03v3 L=0.28U W=1U AS=0.65P AD=0.65P PS=3.3U
+ PD=3.3U
M$176 VDD RSTn \$513 VDD pfet_03v3 L=0.28U W=1U AS=0.65P AD=0.65P PS=3.3U
+ PD=3.3U
M$177 \$513 \$515 VDD VDD pfet_03v3 L=0.28U W=1U AS=0.65P AD=0.65P PS=3.3U
+ PD=3.3U
M$178 VDD \$512 \$515 VDD pfet_03v3 L=0.28U W=1U AS=0.65P AD=0.65P PS=3.3U
+ PD=3.3U
M$179 \$517 \$505 \$515 VDD pfet_03v3 L=0.28U W=1U AS=0.65P AD=0.65P PS=3.3U
+ PD=3.3U
M$180 \$564 RSTn VDD VDD pfet_03v3 L=0.28U W=1U AS=0.65P AD=0.65P PS=3.3U
+ PD=3.3U
M$181 \$564 \$556 VDD VDD pfet_03v3 L=0.28U W=1U AS=0.65P AD=0.65P PS=3.3U
+ PD=3.3U
M$182 \$588 \$564 \$556 VDD pfet_03v3 L=0.28U W=1U AS=0.65P AD=0.65P PS=3.3U
+ PD=3.3U
M$183 VDD \$557 \$588 VDD pfet_03v3 L=0.28U W=1U AS=0.65P AD=0.65P PS=3.3U
+ PD=3.3U
M$184 Q4 \$564 VDD VDD pfet_03v3 L=0.28U W=1U AS=0.65P AD=0.65P PS=3.3U PD=3.3U
M$185 \$567 \$564 VDD VDD pfet_03v3 L=0.28U W=1U AS=0.65P AD=0.65P PS=3.3U
+ PD=3.3U
M$186 Qb4 \$567 VDD VDD pfet_03v3 L=0.28U W=1U AS=0.65P AD=0.65P PS=3.3U PD=3.3U
M$187 \$605 CLK VDD VDD pfet_03v3 L=0.28U W=1U AS=0.65P AD=0.65P PS=3.3U PD=3.3U
M$188 \$606 \$605 VDD VDD pfet_03v3 L=0.28U W=1U AS=0.65P AD=0.65P PS=3.3U
+ PD=3.3U
M$189 \$637 \$606 VDD VDD pfet_03v3 L=0.28U W=1U AS=0.65P AD=0.65P PS=3.3U
+ PD=3.3U
M$190 \$559 D4 \$587 VDD pfet_03v3 L=0.28U W=1U AS=0.65P AD=0.65P PS=3.3U
+ PD=3.3U
M$191 \$560 \$555 \$559 VDD pfet_03v3 L=0.28U W=1U AS=0.65P AD=0.65P PS=3.3U
+ PD=3.3U
M$192 VDD RSTn \$560 VDD pfet_03v3 L=0.28U W=1U AS=0.65P AD=0.65P PS=3.3U
+ PD=3.3U
M$193 \$560 \$562 VDD VDD pfet_03v3 L=0.28U W=1U AS=0.65P AD=0.65P PS=3.3U
+ PD=3.3U
M$194 VDD \$559 \$562 VDD pfet_03v3 L=0.28U W=1U AS=0.65P AD=0.65P PS=3.3U
+ PD=3.3U
M$195 \$556 \$555 \$562 VDD pfet_03v3 L=0.28U W=1U AS=0.65P AD=0.65P PS=3.3U
+ PD=3.3U
M$196 \$619 RSTn VDD VDD pfet_03v3 L=0.28U W=1U AS=0.65P AD=0.65P PS=3.3U
+ PD=3.3U
M$197 \$619 \$617 VDD VDD pfet_03v3 L=0.28U W=1U AS=0.65P AD=0.65P PS=3.3U
+ PD=3.3U
M$198 \$638 \$619 \$617 VDD pfet_03v3 L=0.28U W=1U AS=0.65P AD=0.65P PS=3.3U
+ PD=3.3U
M$199 VDD \$606 \$638 VDD pfet_03v3 L=0.28U W=1U AS=0.65P AD=0.65P PS=3.3U
+ PD=3.3U
M$200 Q3 \$619 VDD VDD pfet_03v3 L=0.28U W=1U AS=0.65P AD=0.65P PS=3.3U PD=3.3U
M$201 \$609 \$619 VDD VDD pfet_03v3 L=0.28U W=1U AS=0.65P AD=0.65P PS=3.3U
+ PD=3.3U
M$202 Qb3 \$609 VDD VDD pfet_03v3 L=0.28U W=1U AS=0.65P AD=0.65P PS=3.3U PD=3.3U
M$203 \$655 CLK VDD VDD pfet_03v3 L=0.28U W=1U AS=0.65P AD=0.65P PS=3.3U PD=3.3U
M$204 \$657 \$655 VDD VDD pfet_03v3 L=0.28U W=1U AS=0.65P AD=0.65P PS=3.3U
+ PD=3.3U
M$205 \$687 \$657 VDD VDD pfet_03v3 L=0.28U W=1U AS=0.65P AD=0.65P PS=3.3U
+ PD=3.3U
M$206 \$612 D3 \$637 VDD pfet_03v3 L=0.28U W=1U AS=0.65P AD=0.65P PS=3.3U
+ PD=3.3U
M$207 \$613 \$605 \$612 VDD pfet_03v3 L=0.28U W=1U AS=0.65P AD=0.65P PS=3.3U
+ PD=3.3U
M$208 VDD RSTn \$613 VDD pfet_03v3 L=0.28U W=1U AS=0.65P AD=0.65P PS=3.3U
+ PD=3.3U
M$209 \$613 \$615 VDD VDD pfet_03v3 L=0.28U W=1U AS=0.65P AD=0.65P PS=3.3U
+ PD=3.3U
M$210 VDD \$612 \$615 VDD pfet_03v3 L=0.28U W=1U AS=0.65P AD=0.65P PS=3.3U
+ PD=3.3U
M$211 \$617 \$605 \$615 VDD pfet_03v3 L=0.28U W=1U AS=0.65P AD=0.65P PS=3.3U
+ PD=3.3U
M$212 \$664 RSTn VDD VDD pfet_03v3 L=0.28U W=1U AS=0.65P AD=0.65P PS=3.3U
+ PD=3.3U
M$213 \$664 \$656 VDD VDD pfet_03v3 L=0.28U W=1U AS=0.65P AD=0.65P PS=3.3U
+ PD=3.3U
M$214 \$688 \$664 \$656 VDD pfet_03v3 L=0.28U W=1U AS=0.65P AD=0.65P PS=3.3U
+ PD=3.3U
M$215 VDD \$657 \$688 VDD pfet_03v3 L=0.28U W=1U AS=0.65P AD=0.65P PS=3.3U
+ PD=3.3U
M$216 Q2 \$664 VDD VDD pfet_03v3 L=0.28U W=1U AS=0.65P AD=0.65P PS=3.3U PD=3.3U
M$217 \$667 \$664 VDD VDD pfet_03v3 L=0.28U W=1U AS=0.65P AD=0.65P PS=3.3U
+ PD=3.3U
M$218 Qb2 \$667 VDD VDD pfet_03v3 L=0.28U W=1U AS=0.65P AD=0.65P PS=3.3U PD=3.3U
M$219 \$705 CLK VDD VDD pfet_03v3 L=0.28U W=1U AS=0.65P AD=0.65P PS=3.3U PD=3.3U
M$220 \$707 \$705 VDD VDD pfet_03v3 L=0.28U W=1U AS=0.65P AD=0.65P PS=3.3U
+ PD=3.3U
M$221 \$737 \$707 VDD VDD pfet_03v3 L=0.28U W=1U AS=0.65P AD=0.65P PS=3.3U
+ PD=3.3U
M$222 \$659 D2 \$687 VDD pfet_03v3 L=0.28U W=1U AS=0.65P AD=0.65P PS=3.3U
+ PD=3.3U
M$223 \$660 \$655 \$659 VDD pfet_03v3 L=0.28U W=1U AS=0.65P AD=0.65P PS=3.3U
+ PD=3.3U
M$224 VDD RSTn \$660 VDD pfet_03v3 L=0.28U W=1U AS=0.65P AD=0.65P PS=3.3U
+ PD=3.3U
M$225 \$660 \$662 VDD VDD pfet_03v3 L=0.28U W=1U AS=0.65P AD=0.65P PS=3.3U
+ PD=3.3U
M$226 VDD \$659 \$662 VDD pfet_03v3 L=0.28U W=1U AS=0.65P AD=0.65P PS=3.3U
+ PD=3.3U
M$227 \$656 \$655 \$662 VDD pfet_03v3 L=0.28U W=1U AS=0.65P AD=0.65P PS=3.3U
+ PD=3.3U
M$228 \$714 RSTn VDD VDD pfet_03v3 L=0.28U W=1U AS=0.65P AD=0.65P PS=3.3U
+ PD=3.3U
M$229 \$714 \$706 VDD VDD pfet_03v3 L=0.28U W=1U AS=0.65P AD=0.65P PS=3.3U
+ PD=3.3U
M$230 \$738 \$714 \$706 VDD pfet_03v3 L=0.28U W=1U AS=0.65P AD=0.65P PS=3.3U
+ PD=3.3U
M$231 VDD \$707 \$738 VDD pfet_03v3 L=0.28U W=1U AS=0.65P AD=0.65P PS=3.3U
+ PD=3.3U
M$232 Q1 \$714 VDD VDD pfet_03v3 L=0.28U W=1U AS=0.65P AD=0.65P PS=3.3U PD=3.3U
M$233 \$717 \$714 VDD VDD pfet_03v3 L=0.28U W=1U AS=0.65P AD=0.65P PS=3.3U
+ PD=3.3U
M$234 Qb1 \$717 VDD VDD pfet_03v3 L=0.28U W=1U AS=0.65P AD=0.65P PS=3.3U PD=3.3U
M$235 \$755 CLK VDD VDD pfet_03v3 L=0.28U W=1U AS=0.65P AD=0.65P PS=3.3U PD=3.3U
M$236 \$757 \$755 VDD VDD pfet_03v3 L=0.28U W=1U AS=0.65P AD=0.65P PS=3.3U
+ PD=3.3U
M$237 \$787 \$757 VDD VDD pfet_03v3 L=0.28U W=1U AS=0.65P AD=0.65P PS=3.3U
+ PD=3.3U
M$238 \$709 D1 \$737 VDD pfet_03v3 L=0.28U W=1U AS=0.65P AD=0.65P PS=3.3U
+ PD=3.3U
M$239 \$710 \$705 \$709 VDD pfet_03v3 L=0.28U W=1U AS=0.65P AD=0.65P PS=3.3U
+ PD=3.3U
M$240 VDD RSTn \$710 VDD pfet_03v3 L=0.28U W=1U AS=0.65P AD=0.65P PS=3.3U
+ PD=3.3U
M$241 \$710 \$712 VDD VDD pfet_03v3 L=0.28U W=1U AS=0.65P AD=0.65P PS=3.3U
+ PD=3.3U
M$242 VDD \$709 \$712 VDD pfet_03v3 L=0.28U W=1U AS=0.65P AD=0.65P PS=3.3U
+ PD=3.3U
M$243 \$706 \$705 \$712 VDD pfet_03v3 L=0.28U W=1U AS=0.65P AD=0.65P PS=3.3U
+ PD=3.3U
M$244 \$785 RSTn VDD VDD pfet_03v3 L=0.28U W=1U AS=0.65P AD=0.65P PS=3.3U
+ PD=3.3U
M$245 \$785 \$756 VDD VDD pfet_03v3 L=0.28U W=1U AS=0.65P AD=0.65P PS=3.3U
+ PD=3.3U
M$246 \$788 \$785 \$756 VDD pfet_03v3 L=0.28U W=1U AS=0.65P AD=0.65P PS=3.3U
+ PD=3.3U
M$247 VDD \$757 \$788 VDD pfet_03v3 L=0.28U W=1U AS=0.65P AD=0.65P PS=3.3U
+ PD=3.3U
M$248 Q0 \$785 VDD VDD pfet_03v3 L=0.28U W=1U AS=0.65P AD=0.65P PS=3.3U PD=3.3U
M$249 \$766 \$785 VDD VDD pfet_03v3 L=0.28U W=1U AS=0.65P AD=0.65P PS=3.3U
+ PD=3.3U
M$250 Qb0 \$766 VDD VDD pfet_03v3 L=0.28U W=1U AS=0.65P AD=0.65P PS=3.3U PD=3.3U
M$251 \$759 D0 \$787 VDD pfet_03v3 L=0.28U W=1U AS=0.65P AD=0.65P PS=3.3U
+ PD=3.3U
M$252 \$760 \$755 \$759 VDD pfet_03v3 L=0.28U W=1U AS=0.65P AD=0.65P PS=3.3U
+ PD=3.3U
M$253 VDD RSTn \$760 VDD pfet_03v3 L=0.28U W=1U AS=0.65P AD=0.65P PS=3.3U
+ PD=3.3U
M$254 \$760 \$762 VDD VDD pfet_03v3 L=0.28U W=1U AS=0.65P AD=0.65P PS=3.3U
+ PD=3.3U
M$255 VDD \$759 \$762 VDD pfet_03v3 L=0.28U W=1U AS=0.65P AD=0.65P PS=3.3U
+ PD=3.3U
M$256 \$756 \$755 \$762 VDD pfet_03v3 L=0.28U W=1U AS=0.65P AD=0.65P PS=3.3U
+ PD=3.3U
M$257 \$2 CLK vss vss nfet_03v3 L=0.28U W=1U AS=0.61P AD=0.61P PS=3.22U PD=3.22U
M$258 \$4 \$2 vss vss nfet_03v3 L=0.28U W=1U AS=0.61P AD=0.61P PS=3.22U PD=3.22U
M$259 \$5 \$2 vss vss nfet_03v3 L=0.28U W=1U AS=0.61P AD=0.61P PS=3.22U PD=3.22U
M$260 vss \$2 \$8 vss nfet_03v3 L=0.28U W=1U AS=0.61P AD=0.61P PS=3.22U PD=3.22U
M$261 \$6 \$4 \$14 vss nfet_03v3 L=0.28U W=1U AS=0.61P AD=0.61P PS=3.22U
+ PD=3.22U
M$262 \$7 \$4 \$16 vss nfet_03v3 L=0.28U W=1U AS=0.61P AD=0.61P PS=3.22U
+ PD=3.22U
M$263 \$9 \$19 vss vss nfet_03v3 L=0.28U W=1U AS=0.61P AD=0.61P PS=3.22U
+ PD=3.22U
M$264 Qb15 \$9 vss vss nfet_03v3 L=0.28U W=1U AS=0.61P AD=0.61P PS=3.22U
+ PD=3.22U
M$265 \$14 D15 \$5 vss nfet_03v3 L=0.28U W=1U AS=0.61P AD=0.61P PS=3.22U
+ PD=3.22U
M$266 \$15 RSTn \$6 vss nfet_03v3 L=0.28U W=1U AS=0.61P AD=0.61P PS=3.22U
+ PD=3.22U
M$267 vss \$16 \$15 vss nfet_03v3 L=0.28U W=1U AS=0.61P AD=0.61P PS=3.22U
+ PD=3.22U
M$268 vss \$14 \$16 vss nfet_03v3 L=0.28U W=1U AS=0.61P AD=0.61P PS=3.22U
+ PD=3.22U
M$269 \$18 RSTn vss vss nfet_03v3 L=0.28U W=1U AS=0.61P AD=0.61P PS=3.22U
+ PD=3.22U
M$270 \$19 \$7 \$18 vss nfet_03v3 L=0.28U W=1U AS=0.61P AD=0.61P PS=3.22U
+ PD=3.22U
M$271 \$8 \$19 \$7 vss nfet_03v3 L=0.28U W=1U AS=0.61P AD=0.61P PS=3.22U
+ PD=3.22U
M$272 Q15 \$19 vss vss nfet_03v3 L=0.28U W=1U AS=0.61P AD=0.61P PS=3.22U
+ PD=3.22U
M$273 \$55 CLK vss vss nfet_03v3 L=0.28U W=1U AS=0.61P AD=0.61P PS=3.22U
+ PD=3.22U
M$274 \$57 \$55 vss vss nfet_03v3 L=0.28U W=1U AS=0.61P AD=0.61P PS=3.22U
+ PD=3.22U
M$275 \$58 \$55 vss vss nfet_03v3 L=0.28U W=1U AS=0.61P AD=0.61P PS=3.22U
+ PD=3.22U
M$276 \$60 D14 \$58 vss nfet_03v3 L=0.28U W=1U AS=0.61P AD=0.61P PS=3.22U
+ PD=3.22U
M$277 \$61 \$57 \$60 vss nfet_03v3 L=0.28U W=1U AS=0.61P AD=0.61P PS=3.22U
+ PD=3.22U
M$278 \$62 RSTn \$61 vss nfet_03v3 L=0.28U W=1U AS=0.61P AD=0.61P PS=3.22U
+ PD=3.22U
M$279 vss \$63 \$62 vss nfet_03v3 L=0.28U W=1U AS=0.61P AD=0.61P PS=3.22U
+ PD=3.22U
M$280 vss \$60 \$63 vss nfet_03v3 L=0.28U W=1U AS=0.61P AD=0.61P PS=3.22U
+ PD=3.22U
M$281 \$56 \$57 \$63 vss nfet_03v3 L=0.28U W=1U AS=0.61P AD=0.61P PS=3.22U
+ PD=3.22U
M$282 \$64 RSTn vss vss nfet_03v3 L=0.28U W=1U AS=0.61P AD=0.61P PS=3.22U
+ PD=3.22U
M$283 \$65 \$56 \$64 vss nfet_03v3 L=0.28U W=1U AS=0.61P AD=0.61P PS=3.22U
+ PD=3.22U
M$284 \$66 \$65 \$56 vss nfet_03v3 L=0.28U W=1U AS=0.61P AD=0.61P PS=3.22U
+ PD=3.22U
M$285 vss \$55 \$66 vss nfet_03v3 L=0.28U W=1U AS=0.61P AD=0.61P PS=3.22U
+ PD=3.22U
M$286 Q14 \$65 vss vss nfet_03v3 L=0.28U W=1U AS=0.61P AD=0.61P PS=3.22U
+ PD=3.22U
M$287 \$68 \$65 vss vss nfet_03v3 L=0.28U W=1U AS=0.61P AD=0.61P PS=3.22U
+ PD=3.22U
M$288 Qb14 \$68 vss vss nfet_03v3 L=0.28U W=1U AS=0.61P AD=0.61P PS=3.22U
+ PD=3.22U
M$289 \$105 CLK vss vss nfet_03v3 L=0.28U W=1U AS=0.61P AD=0.61P PS=3.22U
+ PD=3.22U
M$290 \$107 \$105 vss vss nfet_03v3 L=0.28U W=1U AS=0.61P AD=0.61P PS=3.22U
+ PD=3.22U
M$291 \$108 \$105 vss vss nfet_03v3 L=0.28U W=1U AS=0.61P AD=0.61P PS=3.22U
+ PD=3.22U
M$292 \$110 D13 \$108 vss nfet_03v3 L=0.28U W=1U AS=0.61P AD=0.61P PS=3.22U
+ PD=3.22U
M$293 \$111 \$107 \$110 vss nfet_03v3 L=0.28U W=1U AS=0.61P AD=0.61P PS=3.22U
+ PD=3.22U
M$294 \$112 RSTn \$111 vss nfet_03v3 L=0.28U W=1U AS=0.61P AD=0.61P PS=3.22U
+ PD=3.22U
M$295 vss \$113 \$112 vss nfet_03v3 L=0.28U W=1U AS=0.61P AD=0.61P PS=3.22U
+ PD=3.22U
M$296 vss \$110 \$113 vss nfet_03v3 L=0.28U W=1U AS=0.61P AD=0.61P PS=3.22U
+ PD=3.22U
M$297 \$106 \$107 \$113 vss nfet_03v3 L=0.28U W=1U AS=0.61P AD=0.61P PS=3.22U
+ PD=3.22U
M$298 \$114 RSTn vss vss nfet_03v3 L=0.28U W=1U AS=0.61P AD=0.61P PS=3.22U
+ PD=3.22U
M$299 \$115 \$106 \$114 vss nfet_03v3 L=0.28U W=1U AS=0.61P AD=0.61P PS=3.22U
+ PD=3.22U
M$300 \$116 \$115 \$106 vss nfet_03v3 L=0.28U W=1U AS=0.61P AD=0.61P PS=3.22U
+ PD=3.22U
M$301 vss \$105 \$116 vss nfet_03v3 L=0.28U W=1U AS=0.61P AD=0.61P PS=3.22U
+ PD=3.22U
M$302 Q13 \$115 vss vss nfet_03v3 L=0.28U W=1U AS=0.61P AD=0.61P PS=3.22U
+ PD=3.22U
M$303 \$118 \$115 vss vss nfet_03v3 L=0.28U W=1U AS=0.61P AD=0.61P PS=3.22U
+ PD=3.22U
M$304 Qb13 \$118 vss vss nfet_03v3 L=0.28U W=1U AS=0.61P AD=0.61P PS=3.22U
+ PD=3.22U
M$305 \$155 CLK vss vss nfet_03v3 L=0.28U W=1U AS=0.61P AD=0.61P PS=3.22U
+ PD=3.22U
M$306 \$157 \$155 vss vss nfet_03v3 L=0.28U W=1U AS=0.61P AD=0.61P PS=3.22U
+ PD=3.22U
M$307 \$158 \$155 vss vss nfet_03v3 L=0.28U W=1U AS=0.61P AD=0.61P PS=3.22U
+ PD=3.22U
M$308 \$160 D12 \$158 vss nfet_03v3 L=0.28U W=1U AS=0.61P AD=0.61P PS=3.22U
+ PD=3.22U
M$309 \$161 \$157 \$160 vss nfet_03v3 L=0.28U W=1U AS=0.61P AD=0.61P PS=3.22U
+ PD=3.22U
M$310 \$162 RSTn \$161 vss nfet_03v3 L=0.28U W=1U AS=0.61P AD=0.61P PS=3.22U
+ PD=3.22U
M$311 vss \$163 \$162 vss nfet_03v3 L=0.28U W=1U AS=0.61P AD=0.61P PS=3.22U
+ PD=3.22U
M$312 vss \$160 \$163 vss nfet_03v3 L=0.28U W=1U AS=0.61P AD=0.61P PS=3.22U
+ PD=3.22U
M$313 \$156 \$157 \$163 vss nfet_03v3 L=0.28U W=1U AS=0.61P AD=0.61P PS=3.22U
+ PD=3.22U
M$314 \$164 RSTn vss vss nfet_03v3 L=0.28U W=1U AS=0.61P AD=0.61P PS=3.22U
+ PD=3.22U
M$315 \$165 \$156 \$164 vss nfet_03v3 L=0.28U W=1U AS=0.61P AD=0.61P PS=3.22U
+ PD=3.22U
M$316 \$166 \$165 \$156 vss nfet_03v3 L=0.28U W=1U AS=0.61P AD=0.61P PS=3.22U
+ PD=3.22U
M$317 vss \$155 \$166 vss nfet_03v3 L=0.28U W=1U AS=0.61P AD=0.61P PS=3.22U
+ PD=3.22U
M$318 Q12 \$165 vss vss nfet_03v3 L=0.28U W=1U AS=0.61P AD=0.61P PS=3.22U
+ PD=3.22U
M$319 \$168 \$165 vss vss nfet_03v3 L=0.28U W=1U AS=0.61P AD=0.61P PS=3.22U
+ PD=3.22U
M$320 Qb12 \$168 vss vss nfet_03v3 L=0.28U W=1U AS=0.61P AD=0.61P PS=3.22U
+ PD=3.22U
M$321 \$205 CLK vss vss nfet_03v3 L=0.28U W=1U AS=0.61P AD=0.61P PS=3.22U
+ PD=3.22U
M$322 \$207 \$205 vss vss nfet_03v3 L=0.28U W=1U AS=0.61P AD=0.61P PS=3.22U
+ PD=3.22U
M$323 \$208 \$205 vss vss nfet_03v3 L=0.28U W=1U AS=0.61P AD=0.61P PS=3.22U
+ PD=3.22U
M$324 \$210 D11 \$208 vss nfet_03v3 L=0.28U W=1U AS=0.61P AD=0.61P PS=3.22U
+ PD=3.22U
M$325 \$211 \$207 \$210 vss nfet_03v3 L=0.28U W=1U AS=0.61P AD=0.61P PS=3.22U
+ PD=3.22U
M$326 \$212 RSTn \$211 vss nfet_03v3 L=0.28U W=1U AS=0.61P AD=0.61P PS=3.22U
+ PD=3.22U
M$327 vss \$213 \$212 vss nfet_03v3 L=0.28U W=1U AS=0.61P AD=0.61P PS=3.22U
+ PD=3.22U
M$328 vss \$210 \$213 vss nfet_03v3 L=0.28U W=1U AS=0.61P AD=0.61P PS=3.22U
+ PD=3.22U
M$329 \$206 \$207 \$213 vss nfet_03v3 L=0.28U W=1U AS=0.61P AD=0.61P PS=3.22U
+ PD=3.22U
M$330 \$214 RSTn vss vss nfet_03v3 L=0.28U W=1U AS=0.61P AD=0.61P PS=3.22U
+ PD=3.22U
M$331 \$215 \$206 \$214 vss nfet_03v3 L=0.28U W=1U AS=0.61P AD=0.61P PS=3.22U
+ PD=3.22U
M$332 \$216 \$215 \$206 vss nfet_03v3 L=0.28U W=1U AS=0.61P AD=0.61P PS=3.22U
+ PD=3.22U
M$333 vss \$205 \$216 vss nfet_03v3 L=0.28U W=1U AS=0.61P AD=0.61P PS=3.22U
+ PD=3.22U
M$334 Q11 \$215 vss vss nfet_03v3 L=0.28U W=1U AS=0.61P AD=0.61P PS=3.22U
+ PD=3.22U
M$335 \$218 \$215 vss vss nfet_03v3 L=0.28U W=1U AS=0.61P AD=0.61P PS=3.22U
+ PD=3.22U
M$336 Qb11 \$218 vss vss nfet_03v3 L=0.28U W=1U AS=0.61P AD=0.61P PS=3.22U
+ PD=3.22U
M$337 \$255 CLK vss vss nfet_03v3 L=0.28U W=1U AS=0.61P AD=0.61P PS=3.22U
+ PD=3.22U
M$338 \$257 \$255 vss vss nfet_03v3 L=0.28U W=1U AS=0.61P AD=0.61P PS=3.22U
+ PD=3.22U
M$339 \$258 \$255 vss vss nfet_03v3 L=0.28U W=1U AS=0.61P AD=0.61P PS=3.22U
+ PD=3.22U
M$340 \$260 D10 \$258 vss nfet_03v3 L=0.28U W=1U AS=0.61P AD=0.61P PS=3.22U
+ PD=3.22U
M$341 \$261 \$257 \$260 vss nfet_03v3 L=0.28U W=1U AS=0.61P AD=0.61P PS=3.22U
+ PD=3.22U
M$342 \$262 RSTn \$261 vss nfet_03v3 L=0.28U W=1U AS=0.61P AD=0.61P PS=3.22U
+ PD=3.22U
M$343 vss \$263 \$262 vss nfet_03v3 L=0.28U W=1U AS=0.61P AD=0.61P PS=3.22U
+ PD=3.22U
M$344 vss \$260 \$263 vss nfet_03v3 L=0.28U W=1U AS=0.61P AD=0.61P PS=3.22U
+ PD=3.22U
M$345 \$256 \$257 \$263 vss nfet_03v3 L=0.28U W=1U AS=0.61P AD=0.61P PS=3.22U
+ PD=3.22U
M$346 \$264 RSTn vss vss nfet_03v3 L=0.28U W=1U AS=0.61P AD=0.61P PS=3.22U
+ PD=3.22U
M$347 \$265 \$256 \$264 vss nfet_03v3 L=0.28U W=1U AS=0.61P AD=0.61P PS=3.22U
+ PD=3.22U
M$348 \$266 \$265 \$256 vss nfet_03v3 L=0.28U W=1U AS=0.61P AD=0.61P PS=3.22U
+ PD=3.22U
M$349 vss \$255 \$266 vss nfet_03v3 L=0.28U W=1U AS=0.61P AD=0.61P PS=3.22U
+ PD=3.22U
M$350 Q10 \$265 vss vss nfet_03v3 L=0.28U W=1U AS=0.61P AD=0.61P PS=3.22U
+ PD=3.22U
M$351 \$268 \$265 vss vss nfet_03v3 L=0.28U W=1U AS=0.61P AD=0.61P PS=3.22U
+ PD=3.22U
M$352 Qb10 \$268 vss vss nfet_03v3 L=0.28U W=1U AS=0.61P AD=0.61P PS=3.22U
+ PD=3.22U
M$353 \$305 CLK vss vss nfet_03v3 L=0.28U W=1U AS=0.61P AD=0.61P PS=3.22U
+ PD=3.22U
M$354 \$307 \$305 vss vss nfet_03v3 L=0.28U W=1U AS=0.61P AD=0.61P PS=3.22U
+ PD=3.22U
M$355 \$308 \$305 vss vss nfet_03v3 L=0.28U W=1U AS=0.61P AD=0.61P PS=3.22U
+ PD=3.22U
M$356 \$310 D9 \$308 vss nfet_03v3 L=0.28U W=1U AS=0.61P AD=0.61P PS=3.22U
+ PD=3.22U
M$357 \$311 \$307 \$310 vss nfet_03v3 L=0.28U W=1U AS=0.61P AD=0.61P PS=3.22U
+ PD=3.22U
M$358 \$312 RSTn \$311 vss nfet_03v3 L=0.28U W=1U AS=0.61P AD=0.61P PS=3.22U
+ PD=3.22U
M$359 vss \$313 \$312 vss nfet_03v3 L=0.28U W=1U AS=0.61P AD=0.61P PS=3.22U
+ PD=3.22U
M$360 vss \$310 \$313 vss nfet_03v3 L=0.28U W=1U AS=0.61P AD=0.61P PS=3.22U
+ PD=3.22U
M$361 \$306 \$307 \$313 vss nfet_03v3 L=0.28U W=1U AS=0.61P AD=0.61P PS=3.22U
+ PD=3.22U
M$362 \$314 RSTn vss vss nfet_03v3 L=0.28U W=1U AS=0.61P AD=0.61P PS=3.22U
+ PD=3.22U
M$363 \$315 \$306 \$314 vss nfet_03v3 L=0.28U W=1U AS=0.61P AD=0.61P PS=3.22U
+ PD=3.22U
M$364 \$316 \$315 \$306 vss nfet_03v3 L=0.28U W=1U AS=0.61P AD=0.61P PS=3.22U
+ PD=3.22U
M$365 vss \$305 \$316 vss nfet_03v3 L=0.28U W=1U AS=0.61P AD=0.61P PS=3.22U
+ PD=3.22U
M$366 Q9 \$315 vss vss nfet_03v3 L=0.28U W=1U AS=0.61P AD=0.61P PS=3.22U
+ PD=3.22U
M$367 \$318 \$315 vss vss nfet_03v3 L=0.28U W=1U AS=0.61P AD=0.61P PS=3.22U
+ PD=3.22U
M$368 Qb9 \$318 vss vss nfet_03v3 L=0.28U W=1U AS=0.61P AD=0.61P PS=3.22U
+ PD=3.22U
M$369 \$355 CLK vss vss nfet_03v3 L=0.28U W=1U AS=0.61P AD=0.61P PS=3.22U
+ PD=3.22U
M$370 \$357 \$355 vss vss nfet_03v3 L=0.28U W=1U AS=0.61P AD=0.61P PS=3.22U
+ PD=3.22U
M$371 \$358 \$355 vss vss nfet_03v3 L=0.28U W=1U AS=0.61P AD=0.61P PS=3.22U
+ PD=3.22U
M$372 \$359 D8 \$358 vss nfet_03v3 L=0.28U W=1U AS=0.61P AD=0.61P PS=3.22U
+ PD=3.22U
M$373 \$360 \$357 \$359 vss nfet_03v3 L=0.28U W=1U AS=0.61P AD=0.61P PS=3.22U
+ PD=3.22U
M$374 \$361 RSTn \$360 vss nfet_03v3 L=0.28U W=1U AS=0.61P AD=0.61P PS=3.22U
+ PD=3.22U
M$375 vss \$362 \$361 vss nfet_03v3 L=0.28U W=1U AS=0.61P AD=0.61P PS=3.22U
+ PD=3.22U
M$376 vss \$359 \$362 vss nfet_03v3 L=0.28U W=1U AS=0.61P AD=0.61P PS=3.22U
+ PD=3.22U
M$377 \$356 \$357 \$362 vss nfet_03v3 L=0.28U W=1U AS=0.61P AD=0.61P PS=3.22U
+ PD=3.22U
M$378 \$363 RSTn vss vss nfet_03v3 L=0.28U W=1U AS=0.61P AD=0.61P PS=3.22U
+ PD=3.22U
M$379 \$364 \$356 \$363 vss nfet_03v3 L=0.28U W=1U AS=0.61P AD=0.61P PS=3.22U
+ PD=3.22U
M$380 \$365 \$364 \$356 vss nfet_03v3 L=0.28U W=1U AS=0.61P AD=0.61P PS=3.22U
+ PD=3.22U
M$381 vss \$355 \$365 vss nfet_03v3 L=0.28U W=1U AS=0.61P AD=0.61P PS=3.22U
+ PD=3.22U
M$382 Q8 \$364 vss vss nfet_03v3 L=0.28U W=1U AS=0.61P AD=0.61P PS=3.22U
+ PD=3.22U
M$383 \$367 \$364 vss vss nfet_03v3 L=0.28U W=1U AS=0.61P AD=0.61P PS=3.22U
+ PD=3.22U
M$384 Qb8 \$367 vss vss nfet_03v3 L=0.28U W=1U AS=0.61P AD=0.61P PS=3.22U
+ PD=3.22U
M$385 \$405 CLK vss vss nfet_03v3 L=0.28U W=1U AS=0.61P AD=0.61P PS=3.22U
+ PD=3.22U
M$386 \$406 \$405 vss vss nfet_03v3 L=0.28U W=1U AS=0.61P AD=0.61P PS=3.22U
+ PD=3.22U
M$387 \$407 \$405 vss vss nfet_03v3 L=0.28U W=1U AS=0.61P AD=0.61P PS=3.22U
+ PD=3.22U
M$388 \$412 D7 \$407 vss nfet_03v3 L=0.28U W=1U AS=0.61P AD=0.61P PS=3.22U
+ PD=3.22U
M$389 \$413 \$406 \$412 vss nfet_03v3 L=0.28U W=1U AS=0.61P AD=0.61P PS=3.22U
+ PD=3.22U
M$390 \$414 RSTn \$413 vss nfet_03v3 L=0.28U W=1U AS=0.61P AD=0.61P PS=3.22U
+ PD=3.22U
M$391 vss \$415 \$414 vss nfet_03v3 L=0.28U W=1U AS=0.61P AD=0.61P PS=3.22U
+ PD=3.22U
M$392 vss \$412 \$415 vss nfet_03v3 L=0.28U W=1U AS=0.61P AD=0.61P PS=3.22U
+ PD=3.22U
M$393 \$417 \$406 \$415 vss nfet_03v3 L=0.28U W=1U AS=0.61P AD=0.61P PS=3.22U
+ PD=3.22U
M$394 \$418 RSTn vss vss nfet_03v3 L=0.28U W=1U AS=0.61P AD=0.61P PS=3.22U
+ PD=3.22U
M$395 \$419 \$417 \$418 vss nfet_03v3 L=0.28U W=1U AS=0.61P AD=0.61P PS=3.22U
+ PD=3.22U
M$396 \$408 \$419 \$417 vss nfet_03v3 L=0.28U W=1U AS=0.61P AD=0.61P PS=3.22U
+ PD=3.22U
M$397 vss \$405 \$408 vss nfet_03v3 L=0.28U W=1U AS=0.61P AD=0.61P PS=3.22U
+ PD=3.22U
M$398 Q7 \$419 vss vss nfet_03v3 L=0.28U W=1U AS=0.61P AD=0.61P PS=3.22U
+ PD=3.22U
M$399 \$409 \$419 vss vss nfet_03v3 L=0.28U W=1U AS=0.61P AD=0.61P PS=3.22U
+ PD=3.22U
M$400 Qb7 \$409 vss vss nfet_03v3 L=0.28U W=1U AS=0.61P AD=0.61P PS=3.22U
+ PD=3.22U
M$401 \$455 CLK vss vss nfet_03v3 L=0.28U W=1U AS=0.61P AD=0.61P PS=3.22U
+ PD=3.22U
M$402 \$457 \$455 vss vss nfet_03v3 L=0.28U W=1U AS=0.61P AD=0.61P PS=3.22U
+ PD=3.22U
M$403 \$458 \$455 vss vss nfet_03v3 L=0.28U W=1U AS=0.61P AD=0.61P PS=3.22U
+ PD=3.22U
M$404 \$459 D6 \$458 vss nfet_03v3 L=0.28U W=1U AS=0.61P AD=0.61P PS=3.22U
+ PD=3.22U
M$405 \$460 \$457 \$459 vss nfet_03v3 L=0.28U W=1U AS=0.61P AD=0.61P PS=3.22U
+ PD=3.22U
M$406 \$461 RSTn \$460 vss nfet_03v3 L=0.28U W=1U AS=0.61P AD=0.61P PS=3.22U
+ PD=3.22U
M$407 vss \$462 \$461 vss nfet_03v3 L=0.28U W=1U AS=0.61P AD=0.61P PS=3.22U
+ PD=3.22U
M$408 vss \$459 \$462 vss nfet_03v3 L=0.28U W=1U AS=0.61P AD=0.61P PS=3.22U
+ PD=3.22U
M$409 \$456 \$457 \$462 vss nfet_03v3 L=0.28U W=1U AS=0.61P AD=0.61P PS=3.22U
+ PD=3.22U
M$410 \$463 RSTn vss vss nfet_03v3 L=0.28U W=1U AS=0.61P AD=0.61P PS=3.22U
+ PD=3.22U
M$411 \$464 \$456 \$463 vss nfet_03v3 L=0.28U W=1U AS=0.61P AD=0.61P PS=3.22U
+ PD=3.22U
M$412 \$465 \$464 \$456 vss nfet_03v3 L=0.28U W=1U AS=0.61P AD=0.61P PS=3.22U
+ PD=3.22U
M$413 vss \$455 \$465 vss nfet_03v3 L=0.28U W=1U AS=0.61P AD=0.61P PS=3.22U
+ PD=3.22U
M$414 Q6 \$464 vss vss nfet_03v3 L=0.28U W=1U AS=0.61P AD=0.61P PS=3.22U
+ PD=3.22U
M$415 \$467 \$464 vss vss nfet_03v3 L=0.28U W=1U AS=0.61P AD=0.61P PS=3.22U
+ PD=3.22U
M$416 Qb6 \$467 vss vss nfet_03v3 L=0.28U W=1U AS=0.61P AD=0.61P PS=3.22U
+ PD=3.22U
M$417 \$505 CLK vss vss nfet_03v3 L=0.28U W=1U AS=0.61P AD=0.61P PS=3.22U
+ PD=3.22U
M$418 \$506 \$505 vss vss nfet_03v3 L=0.28U W=1U AS=0.61P AD=0.61P PS=3.22U
+ PD=3.22U
M$419 \$507 \$505 vss vss nfet_03v3 L=0.28U W=1U AS=0.61P AD=0.61P PS=3.22U
+ PD=3.22U
M$420 \$512 D5 \$507 vss nfet_03v3 L=0.28U W=1U AS=0.61P AD=0.61P PS=3.22U
+ PD=3.22U
M$421 \$513 \$506 \$512 vss nfet_03v3 L=0.28U W=1U AS=0.61P AD=0.61P PS=3.22U
+ PD=3.22U
M$422 \$514 RSTn \$513 vss nfet_03v3 L=0.28U W=1U AS=0.61P AD=0.61P PS=3.22U
+ PD=3.22U
M$423 vss \$515 \$514 vss nfet_03v3 L=0.28U W=1U AS=0.61P AD=0.61P PS=3.22U
+ PD=3.22U
M$424 vss \$512 \$515 vss nfet_03v3 L=0.28U W=1U AS=0.61P AD=0.61P PS=3.22U
+ PD=3.22U
M$425 \$517 \$506 \$515 vss nfet_03v3 L=0.28U W=1U AS=0.61P AD=0.61P PS=3.22U
+ PD=3.22U
M$426 \$518 RSTn vss vss nfet_03v3 L=0.28U W=1U AS=0.61P AD=0.61P PS=3.22U
+ PD=3.22U
M$427 \$519 \$517 \$518 vss nfet_03v3 L=0.28U W=1U AS=0.61P AD=0.61P PS=3.22U
+ PD=3.22U
M$428 \$508 \$519 \$517 vss nfet_03v3 L=0.28U W=1U AS=0.61P AD=0.61P PS=3.22U
+ PD=3.22U
M$429 vss \$505 \$508 vss nfet_03v3 L=0.28U W=1U AS=0.61P AD=0.61P PS=3.22U
+ PD=3.22U
M$430 Q5 \$519 vss vss nfet_03v3 L=0.28U W=1U AS=0.61P AD=0.61P PS=3.22U
+ PD=3.22U
M$431 \$509 \$519 vss vss nfet_03v3 L=0.28U W=1U AS=0.61P AD=0.61P PS=3.22U
+ PD=3.22U
M$432 Qb5 \$509 vss vss nfet_03v3 L=0.28U W=1U AS=0.61P AD=0.61P PS=3.22U
+ PD=3.22U
M$433 \$555 CLK vss vss nfet_03v3 L=0.28U W=1U AS=0.61P AD=0.61P PS=3.22U
+ PD=3.22U
M$434 \$557 \$555 vss vss nfet_03v3 L=0.28U W=1U AS=0.61P AD=0.61P PS=3.22U
+ PD=3.22U
M$435 \$558 \$555 vss vss nfet_03v3 L=0.28U W=1U AS=0.61P AD=0.61P PS=3.22U
+ PD=3.22U
M$436 \$559 D4 \$558 vss nfet_03v3 L=0.28U W=1U AS=0.61P AD=0.61P PS=3.22U
+ PD=3.22U
M$437 \$560 \$557 \$559 vss nfet_03v3 L=0.28U W=1U AS=0.61P AD=0.61P PS=3.22U
+ PD=3.22U
M$438 \$561 RSTn \$560 vss nfet_03v3 L=0.28U W=1U AS=0.61P AD=0.61P PS=3.22U
+ PD=3.22U
M$439 vss \$562 \$561 vss nfet_03v3 L=0.28U W=1U AS=0.61P AD=0.61P PS=3.22U
+ PD=3.22U
M$440 vss \$559 \$562 vss nfet_03v3 L=0.28U W=1U AS=0.61P AD=0.61P PS=3.22U
+ PD=3.22U
M$441 \$556 \$557 \$562 vss nfet_03v3 L=0.28U W=1U AS=0.61P AD=0.61P PS=3.22U
+ PD=3.22U
M$442 \$563 RSTn vss vss nfet_03v3 L=0.28U W=1U AS=0.61P AD=0.61P PS=3.22U
+ PD=3.22U
M$443 \$564 \$556 \$563 vss nfet_03v3 L=0.28U W=1U AS=0.61P AD=0.61P PS=3.22U
+ PD=3.22U
M$444 \$565 \$564 \$556 vss nfet_03v3 L=0.28U W=1U AS=0.61P AD=0.61P PS=3.22U
+ PD=3.22U
M$445 vss \$555 \$565 vss nfet_03v3 L=0.28U W=1U AS=0.61P AD=0.61P PS=3.22U
+ PD=3.22U
M$446 Q4 \$564 vss vss nfet_03v3 L=0.28U W=1U AS=0.61P AD=0.61P PS=3.22U
+ PD=3.22U
M$447 \$567 \$564 vss vss nfet_03v3 L=0.28U W=1U AS=0.61P AD=0.61P PS=3.22U
+ PD=3.22U
M$448 Qb4 \$567 vss vss nfet_03v3 L=0.28U W=1U AS=0.61P AD=0.61P PS=3.22U
+ PD=3.22U
M$449 \$605 CLK vss vss nfet_03v3 L=0.28U W=1U AS=0.61P AD=0.61P PS=3.22U
+ PD=3.22U
M$450 \$606 \$605 vss vss nfet_03v3 L=0.28U W=1U AS=0.61P AD=0.61P PS=3.22U
+ PD=3.22U
M$451 \$607 \$605 vss vss nfet_03v3 L=0.28U W=1U AS=0.61P AD=0.61P PS=3.22U
+ PD=3.22U
M$452 \$612 D3 \$607 vss nfet_03v3 L=0.28U W=1U AS=0.61P AD=0.61P PS=3.22U
+ PD=3.22U
M$453 \$613 \$606 \$612 vss nfet_03v3 L=0.28U W=1U AS=0.61P AD=0.61P PS=3.22U
+ PD=3.22U
M$454 \$614 RSTn \$613 vss nfet_03v3 L=0.28U W=1U AS=0.61P AD=0.61P PS=3.22U
+ PD=3.22U
M$455 vss \$615 \$614 vss nfet_03v3 L=0.28U W=1U AS=0.61P AD=0.61P PS=3.22U
+ PD=3.22U
M$456 vss \$612 \$615 vss nfet_03v3 L=0.28U W=1U AS=0.61P AD=0.61P PS=3.22U
+ PD=3.22U
M$457 \$617 \$606 \$615 vss nfet_03v3 L=0.28U W=1U AS=0.61P AD=0.61P PS=3.22U
+ PD=3.22U
M$458 \$618 RSTn vss vss nfet_03v3 L=0.28U W=1U AS=0.61P AD=0.61P PS=3.22U
+ PD=3.22U
M$459 \$619 \$617 \$618 vss nfet_03v3 L=0.28U W=1U AS=0.61P AD=0.61P PS=3.22U
+ PD=3.22U
M$460 \$608 \$619 \$617 vss nfet_03v3 L=0.28U W=1U AS=0.61P AD=0.61P PS=3.22U
+ PD=3.22U
M$461 vss \$605 \$608 vss nfet_03v3 L=0.28U W=1U AS=0.61P AD=0.61P PS=3.22U
+ PD=3.22U
M$462 Q3 \$619 vss vss nfet_03v3 L=0.28U W=1U AS=0.61P AD=0.61P PS=3.22U
+ PD=3.22U
M$463 \$609 \$619 vss vss nfet_03v3 L=0.28U W=1U AS=0.61P AD=0.61P PS=3.22U
+ PD=3.22U
M$464 Qb3 \$609 vss vss nfet_03v3 L=0.28U W=1U AS=0.61P AD=0.61P PS=3.22U
+ PD=3.22U
M$465 \$655 CLK vss vss nfet_03v3 L=0.28U W=1U AS=0.61P AD=0.61P PS=3.22U
+ PD=3.22U
M$466 \$657 \$655 vss vss nfet_03v3 L=0.28U W=1U AS=0.61P AD=0.61P PS=3.22U
+ PD=3.22U
M$467 \$658 \$655 vss vss nfet_03v3 L=0.28U W=1U AS=0.61P AD=0.61P PS=3.22U
+ PD=3.22U
M$468 \$659 D2 \$658 vss nfet_03v3 L=0.28U W=1U AS=0.61P AD=0.61P PS=3.22U
+ PD=3.22U
M$469 \$660 \$657 \$659 vss nfet_03v3 L=0.28U W=1U AS=0.61P AD=0.61P PS=3.22U
+ PD=3.22U
M$470 \$661 RSTn \$660 vss nfet_03v3 L=0.28U W=1U AS=0.61P AD=0.61P PS=3.22U
+ PD=3.22U
M$471 vss \$662 \$661 vss nfet_03v3 L=0.28U W=1U AS=0.61P AD=0.61P PS=3.22U
+ PD=3.22U
M$472 vss \$659 \$662 vss nfet_03v3 L=0.28U W=1U AS=0.61P AD=0.61P PS=3.22U
+ PD=3.22U
M$473 \$656 \$657 \$662 vss nfet_03v3 L=0.28U W=1U AS=0.61P AD=0.61P PS=3.22U
+ PD=3.22U
M$474 \$663 RSTn vss vss nfet_03v3 L=0.28U W=1U AS=0.61P AD=0.61P PS=3.22U
+ PD=3.22U
M$475 \$664 \$656 \$663 vss nfet_03v3 L=0.28U W=1U AS=0.61P AD=0.61P PS=3.22U
+ PD=3.22U
M$476 \$665 \$664 \$656 vss nfet_03v3 L=0.28U W=1U AS=0.61P AD=0.61P PS=3.22U
+ PD=3.22U
M$477 vss \$655 \$665 vss nfet_03v3 L=0.28U W=1U AS=0.61P AD=0.61P PS=3.22U
+ PD=3.22U
M$478 Q2 \$664 vss vss nfet_03v3 L=0.28U W=1U AS=0.61P AD=0.61P PS=3.22U
+ PD=3.22U
M$479 \$667 \$664 vss vss nfet_03v3 L=0.28U W=1U AS=0.61P AD=0.61P PS=3.22U
+ PD=3.22U
M$480 Qb2 \$667 vss vss nfet_03v3 L=0.28U W=1U AS=0.61P AD=0.61P PS=3.22U
+ PD=3.22U
M$481 \$705 CLK vss vss nfet_03v3 L=0.28U W=1U AS=0.61P AD=0.61P PS=3.22U
+ PD=3.22U
M$482 \$707 \$705 vss vss nfet_03v3 L=0.28U W=1U AS=0.61P AD=0.61P PS=3.22U
+ PD=3.22U
M$483 \$708 \$705 vss vss nfet_03v3 L=0.28U W=1U AS=0.61P AD=0.61P PS=3.22U
+ PD=3.22U
M$484 \$709 D1 \$708 vss nfet_03v3 L=0.28U W=1U AS=0.61P AD=0.61P PS=3.22U
+ PD=3.22U
M$485 \$710 \$707 \$709 vss nfet_03v3 L=0.28U W=1U AS=0.61P AD=0.61P PS=3.22U
+ PD=3.22U
M$486 \$711 RSTn \$710 vss nfet_03v3 L=0.28U W=1U AS=0.61P AD=0.61P PS=3.22U
+ PD=3.22U
M$487 vss \$712 \$711 vss nfet_03v3 L=0.28U W=1U AS=0.61P AD=0.61P PS=3.22U
+ PD=3.22U
M$488 vss \$709 \$712 vss nfet_03v3 L=0.28U W=1U AS=0.61P AD=0.61P PS=3.22U
+ PD=3.22U
M$489 \$706 \$707 \$712 vss nfet_03v3 L=0.28U W=1U AS=0.61P AD=0.61P PS=3.22U
+ PD=3.22U
M$490 \$713 RSTn vss vss nfet_03v3 L=0.28U W=1U AS=0.61P AD=0.61P PS=3.22U
+ PD=3.22U
M$491 \$714 \$706 \$713 vss nfet_03v3 L=0.28U W=1U AS=0.61P AD=0.61P PS=3.22U
+ PD=3.22U
M$492 \$715 \$714 \$706 vss nfet_03v3 L=0.28U W=1U AS=0.61P AD=0.61P PS=3.22U
+ PD=3.22U
M$493 vss \$705 \$715 vss nfet_03v3 L=0.28U W=1U AS=0.61P AD=0.61P PS=3.22U
+ PD=3.22U
M$494 Q1 \$714 vss vss nfet_03v3 L=0.28U W=1U AS=0.61P AD=0.61P PS=3.22U
+ PD=3.22U
M$495 \$717 \$714 vss vss nfet_03v3 L=0.28U W=1U AS=0.61P AD=0.61P PS=3.22U
+ PD=3.22U
M$496 Qb1 \$717 vss vss nfet_03v3 L=0.28U W=1U AS=0.61P AD=0.61P PS=3.22U
+ PD=3.22U
M$497 \$755 CLK vss vss nfet_03v3 L=0.28U W=1U AS=0.61P AD=0.61P PS=3.22U
+ PD=3.22U
M$498 \$757 \$755 vss vss nfet_03v3 L=0.28U W=1U AS=0.61P AD=0.61P PS=3.22U
+ PD=3.22U
M$499 \$758 \$755 vss vss nfet_03v3 L=0.28U W=1U AS=0.61P AD=0.61P PS=3.22U
+ PD=3.22U
M$500 \$759 D0 \$758 vss nfet_03v3 L=0.28U W=1U AS=0.61P AD=0.61P PS=3.22U
+ PD=3.22U
M$501 \$760 \$757 \$759 vss nfet_03v3 L=0.28U W=1U AS=0.61P AD=0.61P PS=3.22U
+ PD=3.22U
M$502 \$761 RSTn \$760 vss nfet_03v3 L=0.28U W=1U AS=0.61P AD=0.61P PS=3.22U
+ PD=3.22U
M$503 vss \$762 \$761 vss nfet_03v3 L=0.28U W=1U AS=0.61P AD=0.61P PS=3.22U
+ PD=3.22U
M$504 vss \$759 \$762 vss nfet_03v3 L=0.28U W=1U AS=0.61P AD=0.61P PS=3.22U
+ PD=3.22U
M$505 \$756 \$757 \$762 vss nfet_03v3 L=0.28U W=1U AS=0.61P AD=0.61P PS=3.22U
+ PD=3.22U
M$506 \$763 RSTn vss vss nfet_03v3 L=0.28U W=1U AS=0.61P AD=0.61P PS=3.22U
+ PD=3.22U
M$507 \$785 \$756 \$763 vss nfet_03v3 L=0.28U W=1U AS=0.61P AD=0.61P PS=3.22U
+ PD=3.22U
M$508 \$764 \$785 \$756 vss nfet_03v3 L=0.28U W=1U AS=0.61P AD=0.61P PS=3.22U
+ PD=3.22U
M$509 vss \$755 \$764 vss nfet_03v3 L=0.28U W=1U AS=0.61P AD=0.61P PS=3.22U
+ PD=3.22U
M$510 Q0 \$785 vss vss nfet_03v3 L=0.28U W=1U AS=0.61P AD=0.61P PS=3.22U
+ PD=3.22U
M$511 \$766 \$785 vss vss nfet_03v3 L=0.28U W=1U AS=0.61P AD=0.61P PS=3.22U
+ PD=3.22U
M$512 Qb0 \$766 vss vss nfet_03v3 L=0.28U W=1U AS=0.61P AD=0.61P PS=3.22U
+ PD=3.22U
.ENDS PC
