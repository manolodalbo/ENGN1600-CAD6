** sch_path: /foss/designs/ENGN1600-CAD6/schematics/PC/pc.sch
.subckt pc vss vdd Q0 D0 Qb0 CLK RSTn Q1 D1 Q1b Q2 D2 Q2b Q3 D3 Q3b Q4 D4 Q4b Q5 D5 Q5b Q6 D6 Q6b Q7 D7 Q7b Q8 D8 Q8b Q9 D9 Q9b
+ Q10 D10 Q10b Q11 D11 Q11b Q12 D12 Q12b Q13 D13 Q13b Q14 D14 Q14b Q15 D15 Q15b
*.PININFO vdd:B vss:B RSTn:I CLK:I Q0:O Qb0:O D0:I Q1:O Q1b:O D1:I Q2:O Q2b:O D2:I Q3:O Q3b:O D3:I Q4:O Q4b:O D4:I Q5:O Q5b:O D5:I
*+ Q6:O Q6b:O D6:I Q7:O Q7b:O D7:I Q8:O Q8b:O D8:I Q9:O Q9b:O D9:I Q10:O Q10b:O D10:I Q11:O Q11b:O D11:I Q12:O Q12b:O D12:I Q13:O Q13b:O
*+ D13:I Q14:O Q14b:O D14:I Q15:O Q15b:O D15:I
x1 vdd RSTn D0 Q0 Qb0 CLK vss DFF
x2 vdd RSTn D1 Q1 Q1b CLK vss DFF
x3 vdd RSTn D2 Q2 Q2b CLK vss DFF
x4 vdd RSTn D3 Q3 Q3b CLK vss DFF
x5 vdd RSTn D4 Q4 Q4b CLK vss DFF
x6 vdd RSTn D5 Q5 Q5b CLK vss DFF
x7 vdd RSTn D6 Q6 Q6b CLK vss DFF
x8 vdd RSTn D7 Q7 Q7b CLK vss DFF
x9 vdd RSTn D8 Q8 Q8b CLK vss DFF
x10 vdd RSTn D9 Q9 Q9b CLK vss DFF
x11 vdd RSTn D10 Q10 Q10b CLK vss DFF
x12 vdd RSTn D11 Q11 Q11b CLK vss DFF
x13 vdd RSTn D12 Q12 Q12b CLK vss DFF
x14 vdd RSTn D13 Q13 Q13b CLK vss DFF
x15 vdd RSTn D14 Q14 Q14b CLK vss DFF
x16 vdd RSTn D15 Q15 Q15b CLK vss DFF
.ends

* expanding   symbol:  schematics/PC/DFF/DFF.sym # of pins=7
** sym_path: /foss/designs/ENGN1600-CAD6/schematics/PC/DFF/DFF.sym
** sch_path: /foss/designs/ENGN1600-CAD6/schematics/PC/DFF/DFF.sch
.subckt DFF vdd RSTn D Q Qb CLK vss
*.PININFO D:I CLK:I RSTn:I Q:O vdd:B vss:B Qb:O
M1 net1 D net3 vss nfet_03v3 L=0.28u W=1u nf=1 m=1
M2 net1 D net2 vdd pfet_03v3 L=0.28u W=1u nf=1 m=1
M3 net2 c vdd vdd pfet_03v3 L=0.28u W=1u nf=1 m=1
M4 net3 cbar vss vss nfet_03v3 L=0.28u W=1u nf=1 m=1
M5 cbar CLK vss vss nfet_03v3 L=0.28u W=1u nf=1 m=1
M6 cbar CLK vdd vdd pfet_03v3 L=0.28u W=1u nf=1 m=1
M7 c cbar vss vss nfet_03v3 L=0.28u W=1u nf=1 m=1
M8 c cbar vdd vdd pfet_03v3 L=0.28u W=1u nf=1 m=1
M11 net5 RSTn net4 vss nfet_03v3 L=0.28u W=1u nf=1 m=1
M12 net4 net6 vss vss nfet_03v3 L=0.28u W=1u nf=1 m=1
M13 net5 RSTn vdd vdd pfet_03v3 L=0.28u W=1u nf=1 m=1
M14 net5 net6 vdd vdd pfet_03v3 L=0.28u W=1u nf=1 m=1
M15 net6 net1 vss vss nfet_03v3 L=0.28u W=1u nf=1 m=1
M16 net6 net1 vdd vdd pfet_03v3 L=0.28u W=1u nf=1 m=1
M21 net9 net7 net8 vss nfet_03v3 L=0.28u W=1u nf=1 m=1
M22 net8 RSTn vss vss nfet_03v3 L=0.28u W=1u nf=1 m=1
M23 net9 net7 vdd vdd pfet_03v3 L=0.28u W=1u nf=1 m=1
M24 net9 RSTn vdd vdd pfet_03v3 L=0.28u W=1u nf=1 m=1
M25 Q net9 vss vss nfet_03v3 L=0.28u W=1u nf=1 m=1
M26 Q net9 vdd vdd pfet_03v3 L=0.28u W=1u nf=1 m=1
M19 net7 net9 net11 vss nfet_03v3 L=0.28u W=1u nf=1 m=1
M20 net7 net9 net10 vdd pfet_03v3 L=0.28u W=1u nf=1 m=1
M31 net10 c vdd vdd pfet_03v3 L=0.28u W=1u nf=1 m=1
M32 net11 cbar vss vss nfet_03v3 L=0.28u W=1u nf=1 m=1
M35 net12 net9 vss vss nfet_03v3 L=0.28u W=1u nf=1 m=1
M36 net12 net9 vdd vdd pfet_03v3 L=0.28u W=1u nf=1 m=1
M37 Qb net12 vss vss nfet_03v3 L=0.28u W=1u nf=1 m=1
M38 Qb net12 vdd vdd pfet_03v3 L=0.28u W=1u nf=1 m=1
M9 net1 c net5 vss nfet_03v3 L=0.28u W=1u nf=1 m=1
M10 net1 cbar net5 vdd pfet_03v3 L=0.28u W=1u nf=1 m=1
M17 net6 c net7 vss nfet_03v3 L=0.28u W=1u nf=1 m=1
M18 net6 cbar net7 vdd pfet_03v3 L=0.28u W=1u nf=1 m=1
.ends
