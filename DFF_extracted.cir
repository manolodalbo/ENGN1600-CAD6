* Extracted by KLayout with GF180MCU LVS runset on : 17/04/2026 00:36

.SUBCKT DFF vss RSTn CLK VDD D Q Qb
M$1 \$19 \$16 VDD VDD pfet_03v3 L=0.28U W=1U AS=0.65P AD=0.65P PS=3.3U PD=3.3U
M$2 Qb \$19 VDD VDD pfet_03v3 L=0.28U W=1U AS=0.65P AD=0.65P PS=3.3U PD=3.3U
M$3 \$2 CLK VDD VDD pfet_03v3 L=0.28U W=1U AS=0.65P AD=0.65P PS=3.3U PD=3.3U
M$4 \$9 \$2 VDD VDD pfet_03v3 L=0.28U W=1U AS=0.65P AD=0.65P PS=3.3U PD=3.3U
M$5 \$37 \$9 VDD VDD pfet_03v3 L=0.28U W=1U AS=0.65P AD=0.65P PS=3.3U PD=3.3U
M$6 \$16 RSTn VDD VDD pfet_03v3 L=0.28U W=1U AS=0.65P AD=0.65P PS=3.3U PD=3.3U
M$7 \$16 \$14 VDD VDD pfet_03v3 L=0.28U W=1U AS=0.65P AD=0.65P PS=3.3U PD=3.3U
M$8 \$38 \$16 \$14 VDD pfet_03v3 L=0.28U W=1U AS=0.65P AD=0.65P PS=3.3U PD=3.3U
M$9 VDD \$9 \$38 VDD pfet_03v3 L=0.28U W=1U AS=0.65P AD=0.65P PS=3.3U PD=3.3U
M$10 Q \$16 VDD VDD pfet_03v3 L=0.28U W=1U AS=0.65P AD=0.65P PS=3.3U PD=3.3U
M$11 \$8 D \$37 VDD pfet_03v3 L=0.28U W=1U AS=0.65P AD=0.65P PS=3.3U PD=3.3U
M$12 \$10 \$2 \$8 VDD pfet_03v3 L=0.28U W=1U AS=0.65P AD=0.65P PS=3.3U PD=3.3U
M$13 VDD RSTn \$10 VDD pfet_03v3 L=0.28U W=1U AS=0.65P AD=0.65P PS=3.3U PD=3.3U
M$14 \$10 \$12 VDD VDD pfet_03v3 L=0.28U W=1U AS=0.65P AD=0.65P PS=3.3U PD=3.3U
M$15 VDD \$8 \$12 VDD pfet_03v3 L=0.28U W=1U AS=0.65P AD=0.65P PS=3.3U PD=3.3U
M$16 \$14 \$2 \$12 VDD pfet_03v3 L=0.28U W=1U AS=0.65P AD=0.65P PS=3.3U PD=3.3U
M$17 \$2 CLK vss vss nfet_03v3 L=0.28U W=1U AS=0.61P AD=0.61P PS=3.22U PD=3.22U
M$18 \$9 \$2 vss vss nfet_03v3 L=0.28U W=1U AS=0.61P AD=0.61P PS=3.22U PD=3.22U
M$19 vss \$2 \$17 vss nfet_03v3 L=0.28U W=1U AS=0.61P AD=0.61P PS=3.22U PD=3.22U
M$20 \$6 \$2 vss vss nfet_03v3 L=0.28U W=1U AS=0.61P AD=0.61P PS=3.22U PD=3.22U
M$21 \$19 \$16 vss vss nfet_03v3 L=0.28U W=1U AS=0.61P AD=0.61P PS=3.22U
+ PD=3.22U
M$22 Qb \$19 vss vss nfet_03v3 L=0.28U W=1U AS=0.61P AD=0.61P PS=3.22U PD=3.22U
M$23 \$10 \$9 \$8 vss nfet_03v3 L=0.28U W=1U AS=0.61P AD=0.61P PS=3.22U PD=3.22U
M$24 \$14 \$9 \$12 vss nfet_03v3 L=0.28U W=1U AS=0.61P AD=0.61P PS=3.22U
+ PD=3.22U
M$25 \$15 RSTn vss vss nfet_03v3 L=0.28U W=1U AS=0.61P AD=0.61P PS=3.22U
+ PD=3.22U
M$26 \$16 \$14 \$15 vss nfet_03v3 L=0.28U W=1U AS=0.61P AD=0.61P PS=3.22U
+ PD=3.22U
M$27 \$17 \$16 \$14 vss nfet_03v3 L=0.28U W=1U AS=0.61P AD=0.61P PS=3.22U
+ PD=3.22U
M$28 Q \$16 vss vss nfet_03v3 L=0.28U W=1U AS=0.61P AD=0.61P PS=3.22U PD=3.22U
M$29 \$8 D \$6 vss nfet_03v3 L=0.28U W=1U AS=0.61P AD=0.61P PS=3.22U PD=3.22U
M$30 \$11 RSTn \$10 vss nfet_03v3 L=0.28U W=1U AS=0.61P AD=0.61P PS=3.22U
+ PD=3.22U
M$31 vss \$12 \$11 vss nfet_03v3 L=0.28U W=1U AS=0.61P AD=0.61P PS=3.22U
+ PD=3.22U
M$32 vss \$8 \$12 vss nfet_03v3 L=0.28U W=1U AS=0.61P AD=0.61P PS=3.22U PD=3.22U
.ENDS DFF
