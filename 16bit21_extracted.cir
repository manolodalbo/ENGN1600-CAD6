* Extracted by KLayout with GF180MCU LVS runset on : 16/04/2026 18:56

.SUBCKT 16bit21 GND Y0 Y1 Y2 Y3 Y4 Y5 Y6 Y7 Y8 Y9 Y10 Y11 Y12 Y13 Y14 Y15 S B0
+ A0 B1 A1 B2 A2 B3 A3 B4 A4 VDD B5 A5 B6 A6 B7 A7 B8 A8 B9 A9 B10 A10 B11 A11
+ B12 A12 B13 A13 B14 A14 B15 A15
M$1 \$3 S \$195 VDD pfet_03v3 L=0.28U W=2U AS=1.09P AD=0.725P PS=5.09U PD=2.725U
M$2 \$195 B0 \$3 VDD pfet_03v3 L=0.28U W=2U AS=0.725P AD=0.675P PS=2.725U
+ PD=2.675U
M$3 VDD A0 \$195 VDD pfet_03v3 L=0.28U W=2U AS=0.675P AD=0.725P PS=2.675U
+ PD=2.725U
M$4 \$195 \$2 VDD VDD pfet_03v3 L=0.28U W=2U AS=0.725P AD=1.3P PS=2.725U PD=5.3U
M$5 \$6 S \$196 VDD pfet_03v3 L=0.28U W=2U AS=1.09P AD=0.725P PS=5.09U PD=2.725U
M$6 \$196 B1 \$6 VDD pfet_03v3 L=0.28U W=2U AS=0.725P AD=0.675P PS=2.725U
+ PD=2.675U
M$7 VDD A1 \$196 VDD pfet_03v3 L=0.28U W=2U AS=0.675P AD=0.725P PS=2.675U
+ PD=2.725U
M$8 \$196 \$5 VDD VDD pfet_03v3 L=0.28U W=2U AS=0.725P AD=1.3P PS=2.725U PD=5.3U
M$9 \$9 S \$197 VDD pfet_03v3 L=0.28U W=2U AS=1.09P AD=0.725P PS=5.09U PD=2.725U
M$10 \$197 B2 \$9 VDD pfet_03v3 L=0.28U W=2U AS=0.725P AD=0.675P PS=2.725U
+ PD=2.675U
M$11 VDD A2 \$197 VDD pfet_03v3 L=0.28U W=2U AS=0.675P AD=0.725P PS=2.675U
+ PD=2.725U
M$12 \$197 \$8 VDD VDD pfet_03v3 L=0.28U W=2U AS=0.725P AD=1.3P PS=2.725U
+ PD=5.3U
M$13 \$12 S \$198 VDD pfet_03v3 L=0.28U W=2U AS=1.09P AD=0.725P PS=5.09U
+ PD=2.725U
M$14 \$198 B3 \$12 VDD pfet_03v3 L=0.28U W=2U AS=0.725P AD=0.675P PS=2.725U
+ PD=2.675U
M$15 VDD A3 \$198 VDD pfet_03v3 L=0.28U W=2U AS=0.675P AD=0.725P PS=2.675U
+ PD=2.725U
M$16 \$198 \$11 VDD VDD pfet_03v3 L=0.28U W=2U AS=0.725P AD=1.3P PS=2.725U
+ PD=5.3U
M$17 \$15 S \$199 VDD pfet_03v3 L=0.28U W=2U AS=1.09P AD=0.725P PS=5.09U
+ PD=2.725U
M$18 \$199 B4 \$15 VDD pfet_03v3 L=0.28U W=2U AS=0.725P AD=0.675P PS=2.725U
+ PD=2.675U
M$19 VDD A4 \$199 VDD pfet_03v3 L=0.28U W=2U AS=0.675P AD=0.725P PS=2.675U
+ PD=2.725U
M$20 \$199 \$14 VDD VDD pfet_03v3 L=0.28U W=2U AS=0.725P AD=1.3P PS=2.725U
+ PD=5.3U
M$21 \$18 S \$200 VDD pfet_03v3 L=0.28U W=2U AS=1.09P AD=0.725P PS=5.09U
+ PD=2.725U
M$22 \$200 B5 \$18 VDD pfet_03v3 L=0.28U W=2U AS=0.725P AD=0.675P PS=2.725U
+ PD=2.675U
M$23 VDD A5 \$200 VDD pfet_03v3 L=0.28U W=2U AS=0.675P AD=0.725P PS=2.675U
+ PD=2.725U
M$24 \$200 \$17 VDD VDD pfet_03v3 L=0.28U W=2U AS=0.725P AD=1.3P PS=2.725U
+ PD=5.3U
M$25 \$21 S \$201 VDD pfet_03v3 L=0.28U W=2U AS=1.09P AD=0.725P PS=5.09U
+ PD=2.725U
M$26 \$201 B6 \$21 VDD pfet_03v3 L=0.28U W=2U AS=0.725P AD=0.675P PS=2.725U
+ PD=2.675U
M$27 VDD A6 \$201 VDD pfet_03v3 L=0.28U W=2U AS=0.675P AD=0.725P PS=2.675U
+ PD=2.725U
M$28 \$201 \$20 VDD VDD pfet_03v3 L=0.28U W=2U AS=0.725P AD=1.3P PS=2.725U
+ PD=5.3U
M$29 \$24 S \$202 VDD pfet_03v3 L=0.28U W=2U AS=1.09P AD=0.725P PS=5.09U
+ PD=2.725U
M$30 \$202 B7 \$24 VDD pfet_03v3 L=0.28U W=2U AS=0.725P AD=0.675P PS=2.725U
+ PD=2.675U
M$31 VDD A7 \$202 VDD pfet_03v3 L=0.28U W=2U AS=0.675P AD=0.725P PS=2.675U
+ PD=2.725U
M$32 \$202 \$23 VDD VDD pfet_03v3 L=0.28U W=2U AS=0.725P AD=1.3P PS=2.725U
+ PD=5.3U
M$33 \$27 S \$203 VDD pfet_03v3 L=0.28U W=2U AS=1.09P AD=0.725P PS=5.09U
+ PD=2.725U
M$34 \$203 B8 \$27 VDD pfet_03v3 L=0.28U W=2U AS=0.725P AD=0.675P PS=2.725U
+ PD=2.675U
M$35 VDD A8 \$203 VDD pfet_03v3 L=0.28U W=2U AS=0.675P AD=0.725P PS=2.675U
+ PD=2.725U
M$36 \$203 \$26 VDD VDD pfet_03v3 L=0.28U W=2U AS=0.725P AD=1.3P PS=2.725U
+ PD=5.3U
M$37 \$30 S \$204 VDD pfet_03v3 L=0.28U W=2U AS=1.09P AD=0.725P PS=5.09U
+ PD=2.725U
M$38 \$204 B9 \$30 VDD pfet_03v3 L=0.28U W=2U AS=0.725P AD=0.675P PS=2.725U
+ PD=2.675U
M$39 VDD A9 \$204 VDD pfet_03v3 L=0.28U W=2U AS=0.675P AD=0.725P PS=2.675U
+ PD=2.725U
M$40 \$204 \$29 VDD VDD pfet_03v3 L=0.28U W=2U AS=0.725P AD=1.3P PS=2.725U
+ PD=5.3U
M$41 \$33 S \$205 VDD pfet_03v3 L=0.28U W=2U AS=1.09P AD=0.725P PS=5.09U
+ PD=2.725U
M$42 \$205 B10 \$33 VDD pfet_03v3 L=0.28U W=2U AS=0.725P AD=0.675P PS=2.725U
+ PD=2.675U
M$43 VDD A10 \$205 VDD pfet_03v3 L=0.28U W=2U AS=0.675P AD=0.725P PS=2.675U
+ PD=2.725U
M$44 \$205 \$32 VDD VDD pfet_03v3 L=0.28U W=2U AS=0.725P AD=1.3P PS=2.725U
+ PD=5.3U
M$45 \$36 S \$206 VDD pfet_03v3 L=0.28U W=2U AS=1.09P AD=0.725P PS=5.09U
+ PD=2.725U
M$46 \$206 B11 \$36 VDD pfet_03v3 L=0.28U W=2U AS=0.725P AD=0.675P PS=2.725U
+ PD=2.675U
M$47 VDD A11 \$206 VDD pfet_03v3 L=0.28U W=2U AS=0.675P AD=0.725P PS=2.675U
+ PD=2.725U
M$48 \$206 \$35 VDD VDD pfet_03v3 L=0.28U W=2U AS=0.725P AD=1.3P PS=2.725U
+ PD=5.3U
M$49 \$39 S \$207 VDD pfet_03v3 L=0.28U W=2U AS=1.09P AD=0.725P PS=5.09U
+ PD=2.725U
M$50 \$207 B12 \$39 VDD pfet_03v3 L=0.28U W=2U AS=0.725P AD=0.675P PS=2.725U
+ PD=2.675U
M$51 VDD A12 \$207 VDD pfet_03v3 L=0.28U W=2U AS=0.675P AD=0.725P PS=2.675U
+ PD=2.725U
M$52 \$207 \$38 VDD VDD pfet_03v3 L=0.28U W=2U AS=0.725P AD=1.3P PS=2.725U
+ PD=5.3U
M$53 \$42 S \$208 VDD pfet_03v3 L=0.28U W=2U AS=1.09P AD=0.725P PS=5.09U
+ PD=2.725U
M$54 \$208 B13 \$42 VDD pfet_03v3 L=0.28U W=2U AS=0.725P AD=0.675P PS=2.725U
+ PD=2.675U
M$55 VDD A13 \$208 VDD pfet_03v3 L=0.28U W=2U AS=0.675P AD=0.725P PS=2.675U
+ PD=2.725U
M$56 \$208 \$41 VDD VDD pfet_03v3 L=0.28U W=2U AS=0.725P AD=1.3P PS=2.725U
+ PD=5.3U
M$57 \$45 S \$209 VDD pfet_03v3 L=0.28U W=2U AS=1.09P AD=0.725P PS=5.09U
+ PD=2.725U
M$58 \$209 B14 \$45 VDD pfet_03v3 L=0.28U W=2U AS=0.725P AD=0.675P PS=2.725U
+ PD=2.675U
M$59 VDD A14 \$209 VDD pfet_03v3 L=0.28U W=2U AS=0.675P AD=0.725P PS=2.675U
+ PD=2.725U
M$60 \$209 \$44 VDD VDD pfet_03v3 L=0.28U W=2U AS=0.725P AD=1.3P PS=2.725U
+ PD=5.3U
M$61 \$48 S \$210 VDD pfet_03v3 L=0.28U W=2U AS=1.09P AD=0.725P PS=5.09U
+ PD=2.725U
M$62 \$210 B15 \$48 VDD pfet_03v3 L=0.28U W=2U AS=0.725P AD=0.675P PS=2.725U
+ PD=2.675U
M$63 VDD A15 \$210 VDD pfet_03v3 L=0.28U W=2U AS=0.675P AD=0.725P PS=2.675U
+ PD=2.725U
M$64 \$210 \$47 VDD VDD pfet_03v3 L=0.28U W=2U AS=0.725P AD=1.3P PS=2.725U
+ PD=5.3U
M$65 \$2 S VDD VDD pfet_03v3 L=0.28U W=1U AS=0.635P AD=0.65P PS=3.27U PD=3.3U
M$66 Y0 \$3 VDD VDD pfet_03v3 L=0.28U W=1U AS=0.53P AD=0.52P PS=3.06U PD=3.04U
M$67 \$5 S VDD VDD pfet_03v3 L=0.28U W=1U AS=0.55P AD=0.65P PS=3.1U PD=3.3U
M$68 Y1 \$6 VDD VDD pfet_03v3 L=0.28U W=1U AS=0.53P AD=0.52P PS=3.06U PD=3.04U
M$69 \$8 S VDD VDD pfet_03v3 L=0.28U W=1U AS=0.635P AD=0.65P PS=3.27U PD=3.3U
M$70 Y2 \$9 VDD VDD pfet_03v3 L=0.28U W=1U AS=0.53P AD=0.52P PS=3.06U PD=3.04U
M$71 \$11 S VDD VDD pfet_03v3 L=0.28U W=1U AS=0.55P AD=0.65P PS=3.1U PD=3.3U
M$72 Y3 \$12 VDD VDD pfet_03v3 L=0.28U W=1U AS=0.53P AD=0.52P PS=3.06U PD=3.04U
M$73 \$14 S VDD VDD pfet_03v3 L=0.28U W=1U AS=0.635P AD=0.65P PS=3.27U PD=3.3U
M$74 Y4 \$15 VDD VDD pfet_03v3 L=0.28U W=1U AS=0.53P AD=0.52P PS=3.06U PD=3.04U
M$75 \$17 S VDD VDD pfet_03v3 L=0.28U W=1U AS=0.55P AD=0.65P PS=3.1U PD=3.3U
M$76 Y5 \$18 VDD VDD pfet_03v3 L=0.28U W=1U AS=0.53P AD=0.52P PS=3.06U PD=3.04U
M$77 \$20 S VDD VDD pfet_03v3 L=0.28U W=1U AS=0.635P AD=0.65P PS=3.27U PD=3.3U
M$78 Y6 \$21 VDD VDD pfet_03v3 L=0.28U W=1U AS=0.53P AD=0.52P PS=3.06U PD=3.04U
M$79 \$23 S VDD VDD pfet_03v3 L=0.28U W=1U AS=0.55P AD=0.65P PS=3.1U PD=3.3U
M$80 Y7 \$24 VDD VDD pfet_03v3 L=0.28U W=1U AS=0.53P AD=0.52P PS=3.06U PD=3.04U
M$81 \$26 S VDD VDD pfet_03v3 L=0.28U W=1U AS=0.635P AD=0.65P PS=3.27U PD=3.3U
M$82 Y8 \$27 VDD VDD pfet_03v3 L=0.28U W=1U AS=0.53P AD=0.52P PS=3.06U PD=3.04U
M$83 \$29 S VDD VDD pfet_03v3 L=0.28U W=1U AS=0.55P AD=0.65P PS=3.1U PD=3.3U
M$84 Y9 \$30 VDD VDD pfet_03v3 L=0.28U W=1U AS=0.53P AD=0.52P PS=3.06U PD=3.04U
M$85 \$32 S VDD VDD pfet_03v3 L=0.28U W=1U AS=0.635P AD=0.65P PS=3.27U PD=3.3U
M$86 Y10 \$33 VDD VDD pfet_03v3 L=0.28U W=1U AS=0.53P AD=0.52P PS=3.06U PD=3.04U
M$87 \$35 S VDD VDD pfet_03v3 L=0.28U W=1U AS=0.55P AD=0.65P PS=3.1U PD=3.3U
M$88 Y11 \$36 VDD VDD pfet_03v3 L=0.28U W=1U AS=0.53P AD=0.52P PS=3.06U PD=3.04U
M$89 \$38 S VDD VDD pfet_03v3 L=0.28U W=1U AS=0.635P AD=0.65P PS=3.27U PD=3.3U
M$90 Y12 \$39 VDD VDD pfet_03v3 L=0.28U W=1U AS=0.53P AD=0.52P PS=3.06U PD=3.04U
M$91 \$41 S VDD VDD pfet_03v3 L=0.28U W=1U AS=0.55P AD=0.65P PS=3.1U PD=3.3U
M$92 Y13 \$42 VDD VDD pfet_03v3 L=0.28U W=1U AS=0.53P AD=0.52P PS=3.06U PD=3.04U
M$93 \$44 S VDD VDD pfet_03v3 L=0.28U W=1U AS=0.635P AD=0.65P PS=3.27U PD=3.3U
M$94 Y14 \$45 VDD VDD pfet_03v3 L=0.28U W=1U AS=0.53P AD=0.52P PS=3.06U PD=3.04U
M$95 \$47 S VDD VDD pfet_03v3 L=0.28U W=1U AS=0.55P AD=0.65P PS=3.1U PD=3.3U
M$96 Y15 \$48 VDD VDD pfet_03v3 L=0.28U W=1U AS=0.53P AD=0.52P PS=3.06U PD=3.04U
M$97 \$101 S GND GND nfet_03v3 L=0.28U W=1U AS=0.54P AD=0.3625P PS=3.08U
+ PD=1.725U
M$98 \$3 B0 \$101 GND nfet_03v3 L=0.28U W=1U AS=0.3625P AD=0.3375P PS=1.725U
+ PD=1.675U
M$99 \$103 A0 \$3 GND nfet_03v3 L=0.28U W=1U AS=0.3375P AD=0.3625P PS=1.675U
+ PD=1.725U
M$100 GND \$2 \$103 GND nfet_03v3 L=0.28U W=1U AS=0.3625P AD=0.65P PS=1.725U
+ PD=3.3U
M$101 \$113 S GND GND nfet_03v3 L=0.28U W=1U AS=0.54P AD=0.3625P PS=3.08U
+ PD=1.725U
M$102 \$6 B1 \$113 GND nfet_03v3 L=0.28U W=1U AS=0.3625P AD=0.3375P PS=1.725U
+ PD=1.675U
M$103 \$115 A1 \$6 GND nfet_03v3 L=0.28U W=1U AS=0.3375P AD=0.3625P PS=1.675U
+ PD=1.725U
M$104 GND \$5 \$115 GND nfet_03v3 L=0.28U W=1U AS=0.3625P AD=0.65P PS=1.725U
+ PD=3.3U
M$105 \$123 S GND GND nfet_03v3 L=0.28U W=1U AS=0.54P AD=0.3625P PS=3.08U
+ PD=1.725U
M$106 \$9 B2 \$123 GND nfet_03v3 L=0.28U W=1U AS=0.3625P AD=0.3375P PS=1.725U
+ PD=1.675U
M$107 \$127 A2 \$9 GND nfet_03v3 L=0.28U W=1U AS=0.3375P AD=0.3625P PS=1.675U
+ PD=1.725U
M$108 GND \$8 \$127 GND nfet_03v3 L=0.28U W=1U AS=0.3625P AD=0.65P PS=1.725U
+ PD=3.3U
M$109 \$132 S GND GND nfet_03v3 L=0.28U W=1U AS=0.54P AD=0.3625P PS=3.08U
+ PD=1.725U
M$110 \$12 B3 \$132 GND nfet_03v3 L=0.28U W=1U AS=0.3625P AD=0.3375P PS=1.725U
+ PD=1.675U
M$111 \$136 A3 \$12 GND nfet_03v3 L=0.28U W=1U AS=0.3375P AD=0.3625P PS=1.675U
+ PD=1.725U
M$112 GND \$11 \$136 GND nfet_03v3 L=0.28U W=1U AS=0.3625P AD=0.65P PS=1.725U
+ PD=3.3U
M$113 \$143 S GND GND nfet_03v3 L=0.28U W=1U AS=0.54P AD=0.3625P PS=3.08U
+ PD=1.725U
M$114 \$15 B4 \$143 GND nfet_03v3 L=0.28U W=1U AS=0.3625P AD=0.3375P PS=1.725U
+ PD=1.675U
M$115 \$144 A4 \$15 GND nfet_03v3 L=0.28U W=1U AS=0.3375P AD=0.3625P PS=1.675U
+ PD=1.725U
M$116 GND \$14 \$144 GND nfet_03v3 L=0.28U W=1U AS=0.3625P AD=0.65P PS=1.725U
+ PD=3.3U
M$117 \$154 S GND GND nfet_03v3 L=0.28U W=1U AS=0.54P AD=0.3625P PS=3.08U
+ PD=1.725U
M$118 \$18 B5 \$154 GND nfet_03v3 L=0.28U W=1U AS=0.3625P AD=0.3375P PS=1.725U
+ PD=1.675U
M$119 \$156 A5 \$18 GND nfet_03v3 L=0.28U W=1U AS=0.3375P AD=0.3625P PS=1.675U
+ PD=1.725U
M$120 GND \$17 \$156 GND nfet_03v3 L=0.28U W=1U AS=0.3625P AD=0.65P PS=1.725U
+ PD=3.3U
M$121 \$163 S GND GND nfet_03v3 L=0.28U W=1U AS=0.54P AD=0.3625P PS=3.08U
+ PD=1.725U
M$122 \$21 B6 \$163 GND nfet_03v3 L=0.28U W=1U AS=0.3625P AD=0.3375P PS=1.725U
+ PD=1.675U
M$123 \$164 A6 \$21 GND nfet_03v3 L=0.28U W=1U AS=0.3375P AD=0.3625P PS=1.675U
+ PD=1.725U
M$124 GND \$20 \$164 GND nfet_03v3 L=0.28U W=1U AS=0.3625P AD=0.65P PS=1.725U
+ PD=3.3U
M$125 \$173 S GND GND nfet_03v3 L=0.28U W=1U AS=0.54P AD=0.3625P PS=3.08U
+ PD=1.725U
M$126 \$24 B7 \$173 GND nfet_03v3 L=0.28U W=1U AS=0.3625P AD=0.3375P PS=1.725U
+ PD=1.675U
M$127 \$174 A7 \$24 GND nfet_03v3 L=0.28U W=1U AS=0.3375P AD=0.3625P PS=1.675U
+ PD=1.725U
M$128 GND \$23 \$174 GND nfet_03v3 L=0.28U W=1U AS=0.3625P AD=0.65P PS=1.725U
+ PD=3.3U
M$129 \$185 S GND GND nfet_03v3 L=0.28U W=1U AS=0.54P AD=0.3625P PS=3.08U
+ PD=1.725U
M$130 \$27 B8 \$185 GND nfet_03v3 L=0.28U W=1U AS=0.3625P AD=0.3375P PS=1.725U
+ PD=1.675U
M$131 \$187 A8 \$27 GND nfet_03v3 L=0.28U W=1U AS=0.3375P AD=0.3625P PS=1.675U
+ PD=1.725U
M$132 GND \$26 \$187 GND nfet_03v3 L=0.28U W=1U AS=0.3625P AD=0.65P PS=1.725U
+ PD=3.3U
M$133 \$194 S GND GND nfet_03v3 L=0.28U W=1U AS=0.54P AD=0.3625P PS=3.08U
+ PD=1.725U
M$134 \$30 B9 \$194 GND nfet_03v3 L=0.28U W=1U AS=0.3625P AD=0.3375P PS=1.725U
+ PD=1.675U
M$135 \$191 A9 \$30 GND nfet_03v3 L=0.28U W=1U AS=0.3375P AD=0.3625P PS=1.675U
+ PD=1.725U
M$136 GND \$29 \$191 GND nfet_03v3 L=0.28U W=1U AS=0.3625P AD=0.65P PS=1.725U
+ PD=3.3U
M$137 \$180 S GND GND nfet_03v3 L=0.28U W=1U AS=0.54P AD=0.3625P PS=3.08U
+ PD=1.725U
M$138 \$33 B10 \$180 GND nfet_03v3 L=0.28U W=1U AS=0.3625P AD=0.3375P PS=1.725U
+ PD=1.675U
M$139 \$179 A10 \$33 GND nfet_03v3 L=0.28U W=1U AS=0.3375P AD=0.3625P PS=1.675U
+ PD=1.725U
M$140 GND \$32 \$179 GND nfet_03v3 L=0.28U W=1U AS=0.3625P AD=0.65P PS=1.725U
+ PD=3.3U
M$141 \$166 S GND GND nfet_03v3 L=0.28U W=1U AS=0.54P AD=0.3625P PS=3.08U
+ PD=1.725U
M$142 \$36 B11 \$166 GND nfet_03v3 L=0.28U W=1U AS=0.3625P AD=0.3375P PS=1.725U
+ PD=1.675U
M$143 \$165 A11 \$36 GND nfet_03v3 L=0.28U W=1U AS=0.3375P AD=0.3625P PS=1.675U
+ PD=1.725U
M$144 GND \$35 \$165 GND nfet_03v3 L=0.28U W=1U AS=0.3625P AD=0.65P PS=1.725U
+ PD=3.3U
M$145 \$151 S GND GND nfet_03v3 L=0.28U W=1U AS=0.54P AD=0.3625P PS=3.08U
+ PD=1.725U
M$146 \$39 B12 \$151 GND nfet_03v3 L=0.28U W=1U AS=0.3625P AD=0.3375P PS=1.725U
+ PD=1.675U
M$147 \$149 A12 \$39 GND nfet_03v3 L=0.28U W=1U AS=0.3375P AD=0.3625P PS=1.675U
+ PD=1.725U
M$148 GND \$38 \$149 GND nfet_03v3 L=0.28U W=1U AS=0.3625P AD=0.65P PS=1.725U
+ PD=3.3U
M$149 \$137 S GND GND nfet_03v3 L=0.28U W=1U AS=0.54P AD=0.3625P PS=3.08U
+ PD=1.725U
M$150 \$42 B13 \$137 GND nfet_03v3 L=0.28U W=1U AS=0.3625P AD=0.3375P PS=1.725U
+ PD=1.675U
M$151 \$135 A13 \$42 GND nfet_03v3 L=0.28U W=1U AS=0.3375P AD=0.3625P PS=1.675U
+ PD=1.725U
M$152 GND \$41 \$135 GND nfet_03v3 L=0.28U W=1U AS=0.3625P AD=0.65P PS=1.725U
+ PD=3.3U
M$153 \$122 S GND GND nfet_03v3 L=0.28U W=1U AS=0.54P AD=0.3625P PS=3.08U
+ PD=1.725U
M$154 \$45 B14 \$122 GND nfet_03v3 L=0.28U W=1U AS=0.3625P AD=0.3375P PS=1.725U
+ PD=1.675U
M$155 \$121 A14 \$45 GND nfet_03v3 L=0.28U W=1U AS=0.3375P AD=0.3625P PS=1.675U
+ PD=1.725U
M$156 GND \$44 \$121 GND nfet_03v3 L=0.28U W=1U AS=0.3625P AD=0.65P PS=1.725U
+ PD=3.3U
M$157 \$107 S GND GND nfet_03v3 L=0.28U W=1U AS=0.54P AD=0.3625P PS=3.08U
+ PD=1.725U
M$158 \$48 B15 \$107 GND nfet_03v3 L=0.28U W=1U AS=0.3625P AD=0.3375P PS=1.725U
+ PD=1.675U
M$159 \$104 A15 \$48 GND nfet_03v3 L=0.28U W=1U AS=0.3375P AD=0.3625P PS=1.675U
+ PD=1.725U
M$160 GND \$47 \$104 GND nfet_03v3 L=0.28U W=1U AS=0.3625P AD=0.65P PS=1.725U
+ PD=3.3U
M$161 \$2 S GND GND nfet_03v3 L=0.28U W=0.5U AS=0.3175P AD=0.315P PS=2.27U
+ PD=2.26U
M$162 Y0 \$3 GND GND nfet_03v3 L=0.28U W=0.5U AS=0.265P AD=0.26P PS=2.06U
+ PD=2.04U
M$163 \$5 S GND GND nfet_03v3 L=0.28U W=0.5U AS=0.275P AD=0.315P PS=2.1U
+ PD=2.26U
M$164 Y1 \$6 GND GND nfet_03v3 L=0.28U W=0.5U AS=0.265P AD=0.2625P PS=2.06U
+ PD=2.05U
M$165 \$8 S GND GND nfet_03v3 L=0.28U W=0.5U AS=0.3175P AD=0.315P PS=2.27U
+ PD=2.26U
M$166 Y2 \$9 GND GND nfet_03v3 L=0.28U W=0.5U AS=0.265P AD=0.26P PS=2.06U
+ PD=2.04U
M$167 \$11 S GND GND nfet_03v3 L=0.28U W=0.5U AS=0.275P AD=0.315P PS=2.1U
+ PD=2.26U
M$168 Y3 \$12 GND GND nfet_03v3 L=0.28U W=0.5U AS=0.265P AD=0.2625P PS=2.06U
+ PD=2.05U
M$169 \$14 S GND GND nfet_03v3 L=0.28U W=0.5U AS=0.3175P AD=0.315P PS=2.27U
+ PD=2.26U
M$170 Y4 \$15 GND GND nfet_03v3 L=0.28U W=0.5U AS=0.265P AD=0.26P PS=2.06U
+ PD=2.04U
M$171 \$17 S GND GND nfet_03v3 L=0.28U W=0.5U AS=0.275P AD=0.315P PS=2.1U
+ PD=2.26U
M$172 Y5 \$18 GND GND nfet_03v3 L=0.28U W=0.5U AS=0.265P AD=0.2625P PS=2.06U
+ PD=2.05U
M$173 \$20 S GND GND nfet_03v3 L=0.28U W=0.5U AS=0.3175P AD=0.315P PS=2.27U
+ PD=2.26U
M$174 Y6 \$21 GND GND nfet_03v3 L=0.28U W=0.5U AS=0.265P AD=0.26P PS=2.06U
+ PD=2.04U
M$175 \$23 S GND GND nfet_03v3 L=0.28U W=0.5U AS=0.275P AD=0.315P PS=2.1U
+ PD=2.26U
M$176 Y7 \$24 GND GND nfet_03v3 L=0.28U W=0.5U AS=0.265P AD=0.2625P PS=2.06U
+ PD=2.05U
M$177 \$26 S GND GND nfet_03v3 L=0.28U W=0.5U AS=0.3175P AD=0.315P PS=2.27U
+ PD=2.26U
M$178 Y8 \$27 GND GND nfet_03v3 L=0.28U W=0.5U AS=0.265P AD=0.26P PS=2.06U
+ PD=2.04U
M$179 \$29 S GND GND nfet_03v3 L=0.28U W=0.5U AS=0.275P AD=0.315P PS=2.1U
+ PD=2.26U
M$180 Y9 \$30 GND GND nfet_03v3 L=0.28U W=0.5U AS=0.265P AD=0.2625P PS=2.06U
+ PD=2.05U
M$181 \$32 S GND GND nfet_03v3 L=0.28U W=0.5U AS=0.3175P AD=0.315P PS=2.27U
+ PD=2.26U
M$182 Y10 \$33 GND GND nfet_03v3 L=0.28U W=0.5U AS=0.265P AD=0.26P PS=2.06U
+ PD=2.04U
M$183 \$35 S GND GND nfet_03v3 L=0.28U W=0.5U AS=0.275P AD=0.315P PS=2.1U
+ PD=2.26U
M$184 Y11 \$36 GND GND nfet_03v3 L=0.28U W=0.5U AS=0.265P AD=0.2625P PS=2.06U
+ PD=2.05U
M$185 \$38 S GND GND nfet_03v3 L=0.28U W=0.5U AS=0.3175P AD=0.315P PS=2.27U
+ PD=2.26U
M$186 Y12 \$39 GND GND nfet_03v3 L=0.28U W=0.5U AS=0.265P AD=0.26P PS=2.06U
+ PD=2.04U
M$187 \$41 S GND GND nfet_03v3 L=0.28U W=0.5U AS=0.275P AD=0.315P PS=2.1U
+ PD=2.26U
M$188 Y13 \$42 GND GND nfet_03v3 L=0.28U W=0.5U AS=0.265P AD=0.2625P PS=2.06U
+ PD=2.05U
M$189 \$44 S GND GND nfet_03v3 L=0.28U W=0.5U AS=0.3175P AD=0.315P PS=2.27U
+ PD=2.26U
M$190 Y14 \$45 GND GND nfet_03v3 L=0.28U W=0.5U AS=0.265P AD=0.26P PS=2.06U
+ PD=2.04U
M$191 \$47 S GND GND nfet_03v3 L=0.28U W=0.5U AS=0.275P AD=0.315P PS=2.1U
+ PD=2.26U
M$192 Y15 \$48 GND GND nfet_03v3 L=0.28U W=0.5U AS=0.265P AD=0.2625P PS=2.06U
+ PD=2.05U
.ENDS 16bit21
